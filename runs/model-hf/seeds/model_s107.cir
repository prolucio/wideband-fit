* fitted: 4-port fitted model, reference z0 = 50 Ohm
* port p is PpA (+) to PpB (-); the reference node is P1B
.subckt fitted P1A P1B P2A P2B P3A P3B P4A P4B
* ---- branches
* RLC[1] P1A-P3A
Rrlc1 P1A nrlc1_1 1861.816909
Lrlc1 nrlc1_1 nrlc1_2 2.90857315593e-07
Crlc1 nrlc1_2 P3A 1.06065566714e-14
* RLC[2] P1A-P4A
Rrlc2 P1A nrlc2_1 106.243790521
Lrlc2 nrlc2_1 nrlc2_2 2.65804880407e-08
Crlc2 nrlc2_2 P4A 2.61645534783e-15
* RLC[4] P1A-P2B
Rrlc4 P1A nrlc4_1 909.566762588
Lrlc4 nrlc4_1 nrlc4_2 3.42219373879e-06
Crlc4 nrlc4_2 P2B 1.20719473186e-13
* RLC[5] P1A-P3B
Rrlc5 P1A nrlc5_1 35131.8584088
Lrlc5 nrlc5_1 nrlc5_2 5.34636225914e-05
Crlc5 nrlc5_2 P3B 3.31605450622e-14
* RLC[6] P1A-P4B
Rrlc6 P1A nrlc6_1 707989.171439
Lrlc6 nrlc6_1 nrlc6_2 0.00450688335345
Crlc6 nrlc6_2 P4B 8.57740842935e-13
* RLC[8] P1A-rlc1
Rrlc8 P1A nrlc8_1 20583.8161608
Lrlc8 nrlc8_1 nrlc8_2 0.000123744268919
Crlc8 nrlc8_2 rlc1 1.75094537369e-14
* RLC[10] P1A-rlc3
Rrlc10 P1A nrlc10_1 5.78893684522
Lrlc10 nrlc10_1 nrlc10_2 2.60357557281e-08
Crlc10 nrlc10_2 rlc3 8.89782268655e-13
* RLC[11] P1A-rlc4
Rrlc11 P1A nrlc11_1 3.55022036488
Lrlc11 nrlc11_1 nrlc11_2 3.55867538943e-08
Crlc11 nrlc11_2 rlc4 3.13714970465e-12
* RLC[12] P1A-rlc5
Rrlc12 P1A nrlc12_1 5.00751074164
Lrlc12 nrlc12_1 nrlc12_2 1.29694578819e-08
Crlc12 nrlc12_2 rlc5 5.74692506767e-13
* RLC[13] P1A-rlc6
Rrlc13 P1A nrlc13_1 325.961201666
Lrlc13 nrlc13_1 nrlc13_2 1.20482522193e-06
Crlc13 nrlc13_2 rlc6 1.25993958453e-14
* RLC[14] P1A-rlc7
Rrlc14 P1A nrlc14_1 3558.43395097
Lrlc14 nrlc14_1 nrlc14_2 6.09503331094e-07
Crlc14 nrlc14_2 rlc7 1.02995409142e-14
* RLC[16] P1A-rlc9
Rrlc16 P1A nrlc16_1 82890.5933247
Lrlc16 nrlc16_1 nrlc16_2 2.03788201725e-09
Crlc16 nrlc16_2 rlc9 3.88209141692e-14
* RLC[17] P1A-rlc10
Rrlc17 P1A nrlc17_1 198.409089555
Lrlc17 nrlc17_1 nrlc17_2 5.37175461838e-07
Crlc17 nrlc17_2 rlc10 1.51617917747e-14
* RLC[18] P1A-rlc11
Rrlc18 P1A nrlc18_1 207824.884751
Lrlc18 nrlc18_1 nrlc18_2 0.000524642372329
Crlc18 nrlc18_2 rlc11 9.71583819271e-12
* RLC[19] P1A-rlc12
Rrlc19 P1A nrlc19_1 236892.289687
Lrlc19 nrlc19_1 nrlc19_2 0.615395332875
Crlc19 nrlc19_2 rlc12 0.000148457751905
* RLC[24] P2A-P3A
Rrlc24 P2A nrlc24_1 5659429.40875
Lrlc24 nrlc24_1 nrlc24_2 0.0862220113765
Crlc24 nrlc24_2 P3A 3.43129299079e-15
* RLC[26] P2A-P1B
Rrlc26 P2A nrlc26_1 532180.431204
Lrlc26 nrlc26_1 nrlc26_2 0.584448148923
Crlc26 nrlc26_2 P1B 1.14166564959e-10
* RLC[27] P2A-P2B
Rrlc27 P2A nrlc27_1 1351192.40725
Lrlc27 nrlc27_1 nrlc27_2 0.543983381797
Crlc27 nrlc27_2 P2B 7.20682867646e-12
* RLC[28] P2A-P3B
Rrlc28 P2A nrlc28_1 12161.0270825
Lrlc28 nrlc28_1 nrlc28_2 1.26716525545e-05
Crlc28 nrlc28_2 P3B 3.20394733119e-13
* RLC[32] P2A-rlc2
Rrlc32 P2A nrlc32_1 10.0516907331
Lrlc32 nrlc32_1 nrlc32_2 2.48916169998e-08
Crlc32 nrlc32_2 rlc2 2.73736282349e-13
* RLC[33] P2A-rlc3
Rrlc33 P2A nrlc33_1 1.34025172521
Lrlc33 nrlc33_1 nrlc33_2 4.85525132327e-09
Crlc33 nrlc33_2 rlc3 3.00328437058e-12
* RLC[36] P2A-rlc6
Rrlc36 P2A nrlc36_1 1115.92330387
Lrlc36 nrlc36_1 nrlc36_2 2.35003322459e-06
Crlc36 nrlc36_2 rlc6 2.09682795864e-15
* RLC[37] P2A-rlc7
Rrlc37 P2A nrlc37_1 5331.23249628
Lrlc37 nrlc37_1 nrlc37_2 1.25824243172e-05
Crlc37 nrlc37_2 rlc7 1.56133251212e-14
* RLC[40] P2A-rlc10
Rrlc40 P2A nrlc40_1 7278398.2323
Lrlc40 nrlc40_1 nrlc40_2 0.0235993271841
Crlc40 nrlc40_2 rlc10 3.34106789596e-15
* RLC[43] P2A-rlc13
Rrlc43 P2A nrlc43_1 1453.41385528
Lrlc43 nrlc43_1 nrlc43_2 4.6413959556e-06
Crlc43 nrlc43_2 rlc13 1.42240085781e-14
* RLC[45] P2A-rlc15
Rrlc45 P2A nrlc45_1 861.529193243
Lrlc45 nrlc45_1 nrlc45_2 1.24057719285e-07
Crlc45 nrlc45_2 rlc15 1.52035406325e-13
* RLC[46] P2A-P1B
Rrlc46 P2A nrlc46_1 0.01
Lrlc46 nrlc46_1 nrlc46_2 5.08691983516e-15
Crlc46 nrlc46_2 P1B 4.40223700288e-12
* RLC[47] P3A-P4A
Rrlc47 P3A nrlc47_1 1.77377285097
Lrlc47 nrlc47_1 nrlc47_2 4.36564057174e-07
Crlc47 nrlc47_2 P4A 4.99945454053e-07
* RLC[51] P3A-P4B
Rrlc51 P3A nrlc51_1 2.51067961963
Lrlc51 nrlc51_1 nrlc51_2 4.11590451459e-08
Crlc51 nrlc51_2 P4B 7.25504627873e-12
* RLC[54] P3A-rlc2
Rrlc54 P3A nrlc54_1 17.4724749088
Lrlc54 nrlc54_1 nrlc54_2 7.15205258322e-08
Crlc54 nrlc54_2 rlc2 2.60303098906e-13
* RLC[56] P3A-rlc4
Rrlc56 P3A nrlc56_1 7614.11479783
Lrlc56 nrlc56_1 nrlc56_2 3.8345906774e-05
Crlc56 nrlc56_2 rlc4 1.93192333583e-15
* RLC[58] P3A-rlc6
Rrlc58 P3A nrlc58_1 1410.02693666
Lrlc58 nrlc58_1 nrlc58_2 1.61106976084e-05
Crlc58 nrlc58_2 rlc6 9.01913759187e-15
* RLC[59] P3A-rlc7
Rrlc59 P3A nrlc59_1 5.90713232869
Lrlc59 nrlc59_1 nrlc59_2 1.8608407816e-08
Crlc59 nrlc59_2 rlc7 5.92534041974e-13
* RLC[60] P3A-rlc8
Rrlc60 P3A nrlc60_1 2136800.72591
Lrlc60 nrlc60_1 nrlc60_2 7.36549365396e-08
Crlc60 nrlc60_2 rlc8 8.25015269754e-14
* RLC[62] P3A-rlc10
Rrlc62 P3A nrlc62_1 2.14343624305
Lrlc62 nrlc62_1 nrlc62_2 1.36516294573e-08
Crlc62 nrlc62_2 rlc10 3.30157253175e-12
* RLC[64] P3A-rlc12
Rrlc64 P3A nrlc64_1 2501.53660807
Lrlc64 nrlc64_1 nrlc64_2 1.07080944737e-05
Crlc64 nrlc64_2 rlc12 1.90132325056e-15
* RLC[65] P3A-rlc13
Rrlc65 P3A nrlc65_1 603413.992423
Lrlc65 nrlc65_1 nrlc65_2 1
Crlc65 nrlc65_2 rlc13 3.81459326387e-10
* RLC[67] P3A-rlc15
Rrlc67 P3A nrlc67_1 199.916442246
Lrlc67 nrlc67_1 nrlc67_2 2.00233273498e-06
Crlc67 nrlc67_2 rlc15 5.56668580094e-14
* RLC[68] P3A-P1B
Rrlc68 P3A nrlc68_1 2724.30792103
Lrlc68 nrlc68_1 nrlc68_2 1.01330948765e-05
Crlc68 nrlc68_2 P1B 1.51700570238e-15
* RLC[69] P4A-P1B
Rrlc69 P4A nrlc69_1 132.204963561
Lrlc69 nrlc69_1 nrlc69_2 5.97004553615e-07
Crlc69 nrlc69_2 P1B 3.79524321621e-14
* RLC[71] P4A-P3B
Rrlc71 P4A nrlc71_1 42.1639146402
Lrlc71 nrlc71_1 nrlc71_2 1.83172599638e-07
Crlc71 nrlc71_2 P3B 1.14481720798e-13
* RLC[72] P4A-P4B
Rrlc72 P4A nrlc72_1 0.162466444316
Lrlc72 nrlc72_1 nrlc72_2 3.25386852747e-11
Crlc72 nrlc72_2 P4B 1.36971477454e-12
* RLC[73] P4A-rlc0
Rrlc73 P4A nrlc73_1 3738.30695723
Lrlc73 nrlc73_1 nrlc73_2 4.74749176625e-05
Crlc73 nrlc73_2 rlc0 3.77460745029e-15
* RLC[76] P4A-rlc3
Rrlc76 P4A nrlc76_1 1344.70804608
Lrlc76 nrlc76_1 nrlc76_2 2.55794441566e-06
Crlc76 nrlc76_2 rlc3 1.57178299755e-15
* RLC[77] P4A-rlc4
Rrlc77 P4A nrlc77_1 39.4458689278
Lrlc77 nrlc77_1 nrlc77_2 1.12439154856e-07
Crlc77 nrlc77_2 rlc4 1.02326476705e-13
* RLC[82] P4A-rlc9
Rrlc82 P4A nrlc82_1 1.43329784968
Lrlc82 nrlc82_1 nrlc82_2 2.64095770955e-10
Crlc82 nrlc82_2 rlc9 1.42838749254e-13
* RLC[83] P4A-rlc10
Rrlc83 P4A nrlc83_1 0.01
Lrlc83 nrlc83_1 nrlc83_2 3.01364038428e-14
Crlc83 nrlc83_2 rlc10 5.11097364878e-11
* RLC[86] P4A-rlc13
Rrlc86 P4A nrlc86_1 82732.7852694
Lrlc86 nrlc86_1 nrlc86_2 1
Crlc86 nrlc86_2 rlc13 0.001
* RLC[87] P4A-rlc14
Rrlc87 P4A nrlc87_1 1957397.22802
Lrlc87 nrlc87_1 nrlc87_2 0.387241342698
Crlc87 nrlc87_2 rlc14 6.20339433273e-12
* RLC[88] P4A-rlc15
Rrlc88 P4A nrlc88_1 878535.892275
Lrlc88 nrlc88_1 nrlc88_2 1
Crlc88 nrlc88_2 rlc15 1.5910649563e-11
* RLC[90] P1B-P2B
Rrlc90 P1B nrlc90_1 0.655342572852
Lrlc90 nrlc90_1 nrlc90_2 1.32634325097e-07
Crlc90 nrlc90_2 P2B 1.15228190264e-06
* RLC[91] P1B-P3B
Rrlc91 P1B nrlc91_1 45.7997917959
Lrlc91 nrlc91_1 nrlc91_2 3.97477114106e-07
Crlc91 nrlc91_2 P3B 2.10543874675e-13
* RLC[95] P1B-rlc2
Rrlc95 P1B nrlc95_1 1048.45478829
Lrlc95 nrlc95_1 nrlc95_2 9.32908388195e-07
Crlc95 nrlc95_2 rlc2 3.078527089e-15
* RLC[96] P1B-rlc3
Rrlc96 P1B nrlc96_1 0.0737340482975
Lrlc96 nrlc96_1 nrlc96_2 0.00489303889051
Crlc96 nrlc96_2 rlc3 0.001
* RLC[98] P1B-rlc5
Rrlc98 P1B nrlc98_1 85.70326801
Lrlc98 nrlc98_1 nrlc98_2 3.73784566325e-07
Crlc98 nrlc98_2 rlc5 1.36063513712e-09
* RLC[99] P1B-rlc6
Rrlc99 P1B nrlc99_1 80.08005377
Lrlc99 nrlc99_1 nrlc99_2 5.84252395177e-07
Crlc99 nrlc99_2 rlc6 2.78024874506e-13
* RLC[100] P1B-rlc7
Rrlc100 P1B nrlc100_1 178.517559902
Lrlc100 nrlc100_1 nrlc100_2 1.48583612607e-06
Crlc100 nrlc100_2 rlc7 5.18043847266e-14
* RLC[101] P1B-rlc8
Rrlc101 P1B nrlc101_1 64.3576429225
Lrlc101 nrlc101_1 nrlc101_2 2.83330132754e-08
Crlc101 nrlc101_2 rlc8 1.02054643609e-12
* RLC[103] P1B-rlc10
Rrlc103 P1B nrlc103_1 24780.1465513
Lrlc103 nrlc103_1 nrlc103_2 0.000179067868653
Crlc103 nrlc103_2 rlc10 2.45061279773e-14
* RLC[104] P1B-rlc11
Rrlc104 P1B nrlc104_1 124.135490246
Lrlc104 nrlc104_1 nrlc104_2 1.544223829e-06
Crlc104 nrlc104_2 rlc11 9.00180856958e-11
* RLC[105] P1B-rlc12
Rrlc105 P1B nrlc105_1 2.88343843482
Lrlc105 nrlc105_1 nrlc105_2 4.9105950679e-08
Crlc105 nrlc105_2 rlc12 2.22744418647e-08
* RLC[110] P2B-P3B
Rrlc110 P2B nrlc110_1 3208.49215769
Lrlc110 nrlc110_1 nrlc110_2 2.11588394234e-05
Crlc110 nrlc110_2 P3B 3.40824467475e-14
* RLC[111] P2B-P4B
Rrlc111 P2B nrlc111_1 101.453957025
Lrlc111 nrlc111_1 nrlc111_2 4.41381217877e-05
Crlc111 nrlc111_2 P4B 4.11209195148e-09
* RLC[113] P2B-rlc1
Rrlc113 P2B nrlc113_1 53.7969654048
Lrlc113 nrlc113_1 nrlc113_2 2.70475990556e-05
Crlc113 nrlc113_2 rlc1 1.32423117755e-07
* RLC[114] P2B-rlc2
Rrlc114 P2B nrlc114_1 647.801851051
Lrlc114 nrlc114_1 nrlc114_2 2.57071428725e-06
Crlc114 nrlc114_2 rlc2 1.299518414e-09
* RLC[116] P2B-rlc4
Rrlc116 P2B nrlc116_1 0.01
Lrlc116 nrlc116_1 nrlc116_2 1.8200011839e-08
Crlc116 nrlc116_2 rlc4 3.67472928267e-06
* RLC[117] P2B-rlc5
Rrlc117 P2B nrlc117_1 18.5721200187
Lrlc117 nrlc117_1 nrlc117_2 1.3031958052e-06
Crlc117 nrlc117_2 rlc5 1.37492196797e-08
* RLC[119] P2B-rlc7
Rrlc119 P2B nrlc119_1 0.958602926199
Lrlc119 nrlc119_1 nrlc119_2 4.34661216886e-07
Crlc119 nrlc119_2 rlc7 2.61331766902e-05
* RLC[122] P2B-rlc10
Rrlc122 P2B nrlc122_1 55073.4292768
Lrlc122 nrlc122_1 nrlc122_2 0.000230080318044
Crlc122 nrlc122_2 rlc10 1.78442803173e-14
* RLC[123] P2B-rlc11
Rrlc123 P2B nrlc123_1 1208.85156272
Lrlc123 nrlc123_1 nrlc123_2 1.3500784771e-05
Crlc123 nrlc123_2 rlc11 1.81915580612e-14
* RLC[126] P2B-rlc14
Rrlc126 P2B nrlc126_1 1636.91730075
Lrlc126 nrlc126_1 nrlc126_2 2.45940245667e-06
Crlc126 nrlc126_2 rlc14 3.72284779253e-12
* RLC[128] P2B-P1B
Rrlc128 P2B nrlc128_1 5.17314274806
Lrlc128 nrlc128_1 nrlc128_2 1.86404117316e-08
Crlc128 nrlc128_2 P1B 7.73934249732e-13
* RLC[129] P3B-P4B
Rrlc129 P3B nrlc129_1 46.3193218546
Lrlc129 nrlc129_1 nrlc129_2 3.26539229363e-05
Crlc129 nrlc129_2 P4B 4.47974534559e-09
* RLC[130] P3B-rlc0
Rrlc130 P3B nrlc130_1 491.885366929
Lrlc130 nrlc130_1 nrlc130_2 4.10579325379e-06
Crlc130 nrlc130_2 rlc0 5.79766357764e-13
* RLC[132] P3B-rlc2
Rrlc132 P3B nrlc132_1 1733.767713
Lrlc132 nrlc132_1 nrlc132_2 0.00063661251348
Crlc132 nrlc132_2 rlc2 1.36074788629e-09
* RLC[134] P3B-rlc4
Rrlc134 P3B nrlc134_1 549.946725013
Lrlc134 nrlc134_1 nrlc134_2 3.78915885593e-09
Crlc134 nrlc134_2 rlc4 5.14273348375e-15
* RLC[135] P3B-rlc5
Rrlc135 P3B nrlc135_1 0.01
Lrlc135 nrlc135_1 nrlc135_2 4.15355957579e-15
Crlc135 nrlc135_2 rlc5 1.61934212427e-07
* RLC[136] P3B-rlc6
Rrlc136 P3B nrlc136_1 77.2740624214
Lrlc136 nrlc136_1 nrlc136_2 1.78723520006e-06
Crlc136 nrlc136_2 rlc6 3.3256130151e-13
* RLC[141] P3B-rlc11
Rrlc141 P3B nrlc141_1 0.01
Lrlc141 nrlc141_1 nrlc141_2 6.69654985054e-13
Crlc141 nrlc141_2 rlc11 3.08249660694e-10
* RLC[142] P3B-rlc12
Rrlc142 P3B nrlc142_1 172.520131966
Lrlc142 nrlc142_1 nrlc142_2 2.16647004718e-06
Crlc142 nrlc142_2 rlc12 2.30197196005e-13
* RLC[143] P3B-rlc13
Rrlc143 P3B nrlc143_1 0.054034013621
Lrlc143 nrlc143_1 nrlc143_2 2.14354804905e-07
Crlc143 nrlc143_2 rlc13 3.2361794339e-07
* RLC[145] P3B-rlc15
Rrlc145 P3B nrlc145_1 3.49237000546
Lrlc145 nrlc145_1 nrlc145_2 2.24254456876e-10
Crlc145 nrlc145_2 rlc15 1.40842077786e-13
* RLC[146] P3B-P1B
Rrlc146 P3B nrlc146_1 2.9575081105
Lrlc146 nrlc146_1 nrlc146_2 1.0004739667e-07
Crlc146 nrlc146_2 P1B 4.69717192345e-08
* RLC[147] P4B-rlc0
Rrlc147 P4B nrlc147_1 7797.85729549
Lrlc147 nrlc147_1 nrlc147_2 6.25595528672e-05
Crlc147 nrlc147_2 rlc0 3.60577602162e-14
* RLC[150] P4B-rlc3
Rrlc150 P4B nrlc150_1 74119.2799004
Lrlc150 nrlc150_1 nrlc150_2 0.00162606867948
Crlc150 nrlc150_2 rlc3 3.28877371428e-16
* RLC[152] P4B-rlc5
Rrlc152 P4B nrlc152_1 5.4449484166
Lrlc152 nrlc152_1 nrlc152_2 2.8987806239e-06
Crlc152 nrlc152_2 rlc5 4.35463309353e-07
* RLC[153] P4B-rlc6
Rrlc153 P4B nrlc153_1 1.97447365336
Lrlc153 nrlc153_1 nrlc153_2 5.20410883351e-05
Crlc153 nrlc153_2 rlc6 1.18765041079e-05
* RLC[154] P4B-rlc7
Rrlc154 P4B nrlc154_1 18834.7250305
Lrlc154 nrlc154_1 nrlc154_2 0.000151014207813
Crlc154 nrlc154_2 rlc7 4.72995197018e-16
* RLC[155] P4B-rlc8
Rrlc155 P4B nrlc155_1 2949.0688282
Lrlc155 nrlc155_1 nrlc155_2 1.50920396009e-05
Crlc155 nrlc155_2 rlc8 1.16532745484e-14
* RLC[156] P4B-rlc9
Rrlc156 P4B nrlc156_1 0.09433221359
Lrlc156 nrlc156_1 nrlc156_2 5.18980737112e-08
Crlc156 nrlc156_2 rlc9 6.48020399815e-09
* RLC[159] P4B-rlc12
Rrlc159 P4B nrlc159_1 2804.10394257
Lrlc159 nrlc159_1 nrlc159_2 3.53828865404e-05
Crlc159 nrlc159_2 rlc12 1.19900128769e-14
* RLC[160] P4B-rlc13
Rrlc160 P4B nrlc160_1 208.8898032
Lrlc160 nrlc160_1 nrlc160_2 1.69718490856e-06
Crlc160 nrlc160_2 rlc13 4.32167566289e-14
* RLC[162] P4B-rlc15
Rrlc162 P4B nrlc162_1 96.5078666679
Lrlc162 nrlc162_1 nrlc162_2 7.95820658546e-06
Crlc162 nrlc162_2 rlc15 0.000136273624531
* RLC[164] rlc0-rlc1
Rrlc164 rlc0 nrlc164_1 3.21008184818
Lrlc164 nrlc164_1 nrlc164_2 4.24222326551e-08
Crlc164 nrlc164_2 rlc1 4.57423845138e-12
* RLC[166] rlc0-rlc3
Rrlc166 rlc0 nrlc166_1 434.630415635
Lrlc166 nrlc166_1 nrlc166_2 9.67306297948e-07
Crlc166 nrlc166_2 rlc3 1.13205772542e-12
* RLC[168] rlc0-rlc5
Rrlc168 rlc0 nrlc168_1 1015.78023177
Lrlc168 nrlc168_1 nrlc168_2 4.02602372853e-06
Crlc168 nrlc168_2 rlc5 6.75675170943e-12
* RLC[169] rlc0-rlc6
Rrlc169 rlc0 nrlc169_1 2.09665569573
Lrlc169 nrlc169_1 nrlc169_2 2.02725330463e-08
Crlc169 nrlc169_2 rlc6 5.12402536706e-12
* RLC[170] rlc0-rlc7
Rrlc170 rlc0 nrlc170_1 260.418958614
Lrlc170 nrlc170_1 nrlc170_2 8.42705930701e-06
Crlc170 nrlc170_2 rlc7 1.38066509407e-13
* RLC[171] rlc0-rlc8
Rrlc171 rlc0 nrlc171_1 2.15440893949
Lrlc171 nrlc171_1 nrlc171_2 5.46134316458e-06
Crlc171 nrlc171_2 rlc8 2.00430515787e-05
* RLC[172] rlc0-rlc9
Rrlc172 rlc0 nrlc172_1 970.827442297
Lrlc172 nrlc172_1 nrlc172_2 1.75003747914e-06
Crlc172 nrlc172_2 rlc9 2.06310224803e-15
* RLC[173] rlc0-rlc10
Rrlc173 rlc0 nrlc173_1 53870.6447916
Lrlc173 nrlc173_1 nrlc173_2 0.000510225059265
Crlc173 nrlc173_2 rlc10 3.06066953201e-13
* RLC[174] rlc0-rlc11
Rrlc174 rlc0 nrlc174_1 134.829683964
Lrlc174 nrlc174_1 nrlc174_2 2.41954987395e-07
Crlc174 nrlc174_2 rlc11 1.4788394794e-14
* RLC[175] rlc0-rlc12
Rrlc175 rlc0 nrlc175_1 117.146905726
Lrlc175 nrlc175_1 nrlc175_2 5.93884685573e-07
Crlc175 nrlc175_2 rlc12 6.13974895234e-13
* RLC[176] rlc0-rlc13
Rrlc176 rlc0 nrlc176_1 9.62794493477
Lrlc176 nrlc176_1 nrlc176_2 8.23370190058e-08
Crlc176 nrlc176_2 rlc13 9.86927918241e-13
* RLC[177] rlc0-rlc14
Rrlc177 rlc0 nrlc177_1 25.7945135606
Lrlc177 nrlc177_1 nrlc177_2 2.91291361409e-07
Crlc177 nrlc177_2 rlc14 4.86441267422e-13
* RLC[178] rlc0-rlc15
Rrlc178 rlc0 nrlc178_1 910.677586386
Lrlc178 nrlc178_1 nrlc178_2 2.03411870791e-05
Crlc178 nrlc178_2 rlc15 2.72523833217e-14
* RLC[179] rlc0-P1B
Rrlc179 rlc0 nrlc179_1 57.8449793135
Lrlc179 nrlc179_1 nrlc179_2 3.45615506306e-05
Crlc179 nrlc179_2 P1B 1.47222470555e-09
* RLC[180] rlc1-rlc2
Rrlc180 rlc1 nrlc180_1 676.90247488
Lrlc180 nrlc180_1 nrlc180_2 0.000344402097357
Crlc180 nrlc180_2 rlc2 3.2416459069e-08
* RLC[181] rlc1-rlc3
Rrlc181 rlc1 nrlc181_1 2450.24064271
Lrlc181 nrlc181_1 nrlc181_2 0.000246334795149
Crlc181 nrlc181_2 rlc3 4.06414528139e-10
* RLC[183] rlc1-rlc5
Rrlc183 rlc1 nrlc183_1 0.01
Lrlc183 nrlc183_1 nrlc183_2 1.55248261152e-13
Crlc183 nrlc183_2 rlc5 1.98626644995e-10
* RLC[184] rlc1-rlc6
Rrlc184 rlc1 nrlc184_1 26.3611734287
Lrlc184 nrlc184_1 nrlc184_2 2.78551760134e-07
Crlc184 nrlc184_2 rlc6 4.4538329197e-13
* RLC[185] rlc1-rlc7
Rrlc185 rlc1 nrlc185_1 24.1446118988
Lrlc185 nrlc185_1 nrlc185_2 6.2603834857e-08
Crlc185 nrlc185_2 rlc7 1.40070862649e-08
* RLC[186] rlc1-rlc8
Rrlc186 rlc1 nrlc186_1 143.575538523
Lrlc186 nrlc186_1 nrlc186_2 1.03278891491e-06
Crlc186 nrlc186_2 rlc8 5.5668324568e-14
* RLC[188] rlc1-rlc10
Rrlc188 rlc1 nrlc188_1 1573.34741518
Lrlc188 nrlc188_1 nrlc188_2 1.52485597697e-05
Crlc188 nrlc188_2 rlc10 6.84442635655e-15
* RLC[189] rlc1-rlc11
Rrlc189 rlc1 nrlc189_1 107400.230214
Lrlc189 nrlc189_1 nrlc189_2 2.17755529143e-08
Crlc189 nrlc189_2 rlc11 1.79194832491e-11
* RLC[190] rlc1-rlc12
Rrlc190 rlc1 nrlc190_1 0.01
Lrlc190 nrlc190_1 nrlc190_2 3.97827681115e-13
Crlc190 nrlc190_2 rlc12 2.5700529811e-11
* RLC[191] rlc1-rlc13
Rrlc191 rlc1 nrlc191_1 373.782957166
Lrlc191 nrlc191_1 nrlc191_2 5.94511358605e-07
Crlc191 nrlc191_2 rlc13 3.04281879336e-12
* RLC[192] rlc1-rlc14
Rrlc192 rlc1 nrlc192_1 1.23889095768
Lrlc192 nrlc192_1 nrlc192_2 4.30554049624e-09
Crlc192 nrlc192_2 rlc14 3.11687225174e-12
* RLC[193] rlc1-rlc15
Rrlc193 rlc1 nrlc193_1 77.5729315323
Lrlc193 nrlc193_1 nrlc193_2 7.88861528151e-07
Crlc193 nrlc193_2 rlc15 1.45659179436e-13
* RLC[194] rlc1-P1B
Rrlc194 rlc1 nrlc194_1 238.468145881
Lrlc194 nrlc194_1 nrlc194_2 1.29712935967e-07
Crlc194 nrlc194_2 P1B 4.23771857872e-12
* RLC[195] rlc2-rlc3
Rrlc195 rlc2 nrlc195_1 105.127459116
Lrlc195 nrlc195_1 nrlc195_2 2.9547362637e-07
Crlc195 nrlc195_2 rlc3 2.39396254641e-09
* RLC[196] rlc2-rlc4
Rrlc196 rlc2 nrlc196_1 12293.8808984
Lrlc196 nrlc196_1 nrlc196_2 0.000820823904392
Crlc196 nrlc196_2 rlc4 9.4289619505e-13
* RLC[198] rlc2-rlc6
Rrlc198 rlc2 nrlc198_1 643.792650209
Lrlc198 nrlc198_1 nrlc198_2 1.28534090902e-06
Crlc198 nrlc198_2 rlc6 3.46601951191e-08
* RLC[199] rlc2-rlc7
Rrlc199 rlc2 nrlc199_1 0.347167744535
Lrlc199 nrlc199_1 nrlc199_2 2.30068139748e-10
Crlc199 nrlc199_2 rlc7 2.12097346711e-12
* RLC[202] rlc2-rlc10
Rrlc202 rlc2 nrlc202_1 2817.79659678
Lrlc202 nrlc202_1 nrlc202_2 7.97916199289e-06
Crlc202 nrlc202_2 rlc10 4.93096279017e-14
* RLC[203] rlc2-rlc11
Rrlc203 rlc2 nrlc203_1 3.97780119576
Lrlc203 nrlc203_1 nrlc203_2 8.18860282496e-09
Crlc203 nrlc203_2 rlc11 5.75017615626e-13
* RLC[207] rlc2-rlc15
Rrlc207 rlc2 nrlc207_1 26.5103105711
Lrlc207 nrlc207_1 nrlc207_2 3.23055667904e-10
Crlc207 nrlc207_2 rlc15 6.18340913887e-14
* RLC[208] rlc2-P1B
Rrlc208 rlc2 nrlc208_1 334.33218031
Lrlc208 nrlc208_1 nrlc208_2 5.09053449523e-06
Crlc208 nrlc208_2 P1B 6.02239454753e-07
* RLC[210] rlc3-rlc5
Rrlc210 rlc3 nrlc210_1 150905.392524
Lrlc210 nrlc210_1 nrlc210_2 0.00331683203398
Crlc210 nrlc210_2 rlc5 4.25162719918e-05
* RLC[211] rlc3-rlc6
Rrlc211 rlc3 nrlc211_1 16550.4257219
Lrlc211 nrlc211_1 nrlc211_2 0.000257153522878
Crlc211 nrlc211_2 rlc6 1.04311365327e-15
* RLC[212] rlc3-rlc7
Rrlc212 rlc3 nrlc212_1 100.276373557
Lrlc212 nrlc212_1 nrlc212_2 6.67139200592e-07
Crlc212 nrlc212_2 rlc7 5.79132515015e-13
* RLC[213] rlc3-rlc8
Rrlc213 rlc3 nrlc213_1 403.503600175
Lrlc213 nrlc213_1 nrlc213_2 7.86197761105e-06
Crlc213 nrlc213_2 rlc8 5.36530561908e-14
* RLC[215] rlc3-rlc10
Rrlc215 rlc3 nrlc215_1 355.870425947
Lrlc215 nrlc215_1 nrlc215_2 9.89327437238e-07
Crlc215 nrlc215_2 rlc10 3.97253010541e-13
* RLC[216] rlc3-rlc11
Rrlc216 rlc3 nrlc216_1 454.652300979
Lrlc216 nrlc216_1 nrlc216_2 6.31944795416e-06
Crlc216 nrlc216_2 rlc11 8.33018798959e-05
* RLC[217] rlc3-rlc12
Rrlc217 rlc3 nrlc217_1 0.290497025997
Lrlc217 nrlc217_1 nrlc217_2 1.36454391987e-08
Crlc217 nrlc217_2 rlc12 1.79664233122e-10
* RLC[219] rlc3-rlc14
Rrlc219 rlc3 nrlc219_1 86.3200113231
Lrlc219 nrlc219_1 nrlc219_2 1.68133276863e-06
Crlc219 nrlc219_2 rlc14 2.50719544776e-13
* RLC[220] rlc3-rlc15
Rrlc220 rlc3 nrlc220_1 3990.77427817
Lrlc220 nrlc220_1 nrlc220_2 6.94838869555e-07
Crlc220 nrlc220_2 rlc15 5.41484584083e-14
* RLC[221] rlc3-P1B
Rrlc221 rlc3 nrlc221_1 28.912398257
Lrlc221 nrlc221_1 nrlc221_2 7.85667638042e-07
Crlc221 nrlc221_2 P1B 1.04430683464e-12
* RLC[222] rlc4-rlc5
Rrlc222 rlc4 nrlc222_1 4580.78812283
Lrlc222 nrlc222_1 nrlc222_2 1.61045499777e-05
Crlc222 nrlc222_2 rlc5 5.84090126245e-14
* RLC[223] rlc4-rlc6
Rrlc223 rlc4 nrlc223_1 3549.04087402
Lrlc223 nrlc223_1 nrlc223_2 5.99785787231e-05
Crlc223 nrlc223_2 rlc6 5.29092564943e-15
* RLC[226] rlc4-rlc9
Rrlc226 rlc4 nrlc226_1 26630.1584462
Lrlc226 nrlc226_1 nrlc226_2 0.000781344492255
Crlc226 nrlc226_2 rlc9 1.22420047818e-15
* RLC[227] rlc4-rlc10
Rrlc227 rlc4 nrlc227_1 11493.3979883
Lrlc227 nrlc227_1 nrlc227_2 5.14392710375e-05
Crlc227 nrlc227_2 rlc10 2.515207466e-14
* RLC[228] rlc4-rlc11
Rrlc228 rlc4 nrlc228_1 0.267926012483
Lrlc228 nrlc228_1 nrlc228_2 4.71721035499e-15
Crlc228 nrlc228_2 rlc11 2.84859079745e-12
* RLC[234] rlc5-rlc6
Rrlc234 rlc5 nrlc234_1 8.73740998209
Lrlc234 nrlc234_1 nrlc234_2 1.01527193154e-07
Crlc234 nrlc234_2 rlc6 1.47765974227e-12
* RLC[235] rlc5-rlc7
Rrlc235 rlc5 nrlc235_1 0.107081128857
Lrlc235 nrlc235_1 nrlc235_2 3.69549030739e-09
Crlc235 nrlc235_2 rlc7 3.58099468397e-10
* RLC[237] rlc5-rlc9
Rrlc237 rlc5 nrlc237_1 51.4915188562
Lrlc237 nrlc237_1 nrlc237_2 1.58725857022e-05
Crlc237 nrlc237_2 rlc9 6.73713156052e-06
* RLC[240] rlc5-rlc12
Rrlc240 rlc5 nrlc240_1 73.3740372347
Lrlc240 nrlc240_1 nrlc240_2 3.81593957152e-07
Crlc240 nrlc240_2 rlc12 3.20167217684e-13
* RLC[241] rlc5-rlc13
Rrlc241 rlc5 nrlc241_1 7.38959745826
Lrlc241 nrlc241_1 nrlc241_2 8.63456305722e-08
Crlc241 nrlc241_2 rlc13 1.75693742333e-12
* RLC[243] rlc5-rlc15
Rrlc243 rlc5 nrlc243_1 281.821828841
Lrlc243 nrlc243_1 nrlc243_2 7.95304483045e-06
Crlc243 nrlc243_2 rlc15 8.4375073413e-12
* RLC[247] rlc6-rlc9
Rrlc247 rlc6 nrlc247_1 1.27739316491
Lrlc247 nrlc247_1 nrlc247_2 1.55205052312e-09
Crlc247 nrlc247_2 rlc9 1.056851989e-12
* RLC[248] rlc6-rlc10
Rrlc248 rlc6 nrlc248_1 0.267068527889
Lrlc248 nrlc248_1 nrlc248_2 1.01009612409e-10
Crlc248 nrlc248_2 rlc10 1.57352906806e-12
* RLC[249] rlc6-rlc11
Rrlc249 rlc6 nrlc249_1 123.553347875
Lrlc249 nrlc249_1 nrlc249_2 2.25701316158e-07
Crlc249 nrlc249_2 rlc11 1.6427918764e-14
* RLC[250] rlc6-rlc12
Rrlc250 rlc6 nrlc250_1 4070.90030449
Lrlc250 nrlc250_1 nrlc250_2 1.09636840214e-05
Crlc250 nrlc250_2 rlc12 3.68273702255e-13
* RLC[253] rlc6-rlc15
Rrlc253 rlc6 nrlc253_1 415.806686852
Lrlc253 nrlc253_1 nrlc253_2 3.60451429749e-06
Crlc253 nrlc253_2 rlc15 2.77983371339e-08
* RLC[255] rlc7-rlc8
Rrlc255 rlc7 nrlc255_1 1.7674378857
Lrlc255 nrlc255_1 nrlc255_2 4.19542681927e-08
Crlc255 nrlc255_2 rlc8 2.70789742735e-06
* RLC[257] rlc7-rlc10
Rrlc257 rlc7 nrlc257_1 2.60603367803
Lrlc257 nrlc257_1 nrlc257_2 3.55166084278e-08
Crlc257 nrlc257_2 rlc10 5.81070637126e-12
* RLC[258] rlc7-rlc11
Rrlc258 rlc7 nrlc258_1 20.6909716601
Lrlc258 nrlc258_1 nrlc258_2 7.22087501277e-07
Crlc258 nrlc258_2 rlc11 1.87406886966e-12
* RLC[260] rlc7-rlc13
Rrlc260 rlc7 nrlc260_1 10.9255580828
Lrlc260 nrlc260_1 nrlc260_2 1.09595433894e-07
Crlc260 nrlc260_2 rlc13 1.02014684459e-12
* RLC[261] rlc7-rlc14
Rrlc261 rlc7 nrlc261_1 9.75065884599
Lrlc261 nrlc261_1 nrlc261_2 1.06903881048e-07
Crlc261 nrlc261_2 rlc14 3.660925498e-09
* RLC[263] rlc7-P1B
Rrlc263 rlc7 nrlc263_1 17.2703442226
Lrlc263 nrlc263_1 nrlc263_2 7.16344023538e-07
Crlc263 nrlc263_2 P1B 4.79318378669e-09
* RLC[265] rlc8-rlc10
Rrlc265 rlc8 nrlc265_1 74642.3211187
Lrlc265 nrlc265_1 nrlc265_2 0.00102381275571
Crlc265 nrlc265_2 rlc10 2.31960592396e-11
* RLC[266] rlc8-rlc11
Rrlc266 rlc8 nrlc266_1 0.730917905862
Lrlc266 nrlc266_1 nrlc266_2 0.014839488124
Crlc266 nrlc266_2 rlc11 3.08630760226e-05
* RLC[268] rlc8-rlc13
Rrlc268 rlc8 nrlc268_1 134.31475711
Lrlc268 nrlc268_1 nrlc268_2 1.8517740335e-06
Crlc268 nrlc268_2 rlc13 1.14050716598e-13
* RLC[269] rlc8-rlc14
Rrlc269 rlc8 nrlc269_1 0.0393322556196
Lrlc269 nrlc269_1 nrlc269_2 1.45097565941e-09
Crlc269 nrlc269_2 rlc14 1.04212523319e-09
* RLC[271] rlc8-P1B
Rrlc271 rlc8 nrlc271_1 0.532937195252
Lrlc271 nrlc271_1 nrlc271_2 4.10790127107e-08
Crlc271 nrlc271_2 P1B 1.13587558508e-07
* RLC[272] rlc9-rlc10
Rrlc272 rlc9 nrlc272_1 6361.84628049
Lrlc272 nrlc272_1 nrlc272_2 6.36271914668e-05
Crlc272 nrlc272_2 rlc10 3.8130112795e-15
* RLC[273] rlc9-rlc11
Rrlc273 rlc9 nrlc273_1 9958.14932152
Lrlc273 nrlc273_1 nrlc273_2 0.00188805903251
Crlc273 nrlc273_2 rlc11 2.1524224588e-10
* RLC[277] rlc9-rlc15
Rrlc277 rlc9 nrlc277_1 1145.20704832
Lrlc277 nrlc277_1 nrlc277_2 3.5002362213e-06
Crlc277 nrlc277_2 rlc15 9.94722774385e-07
* RLC[279] rlc10-rlc11
Rrlc279 rlc10 nrlc279_1 3.98171185784
Lrlc279 nrlc279_1 nrlc279_2 5.65472770686e-08
Crlc279 nrlc279_2 rlc11 3.96304980836e-12
* RLC[280] rlc10-rlc12
Rrlc280 rlc10 nrlc280_1 1949555.59132
Lrlc280 nrlc280_1 nrlc280_2 4.80415478357e-08
Crlc280 nrlc280_2 rlc12 6.60456245469e-13
* RLC[281] rlc10-rlc13
Rrlc281 rlc10 nrlc281_1 3898.14235535
Lrlc281 nrlc281_1 nrlc281_2 8.84552990625e-05
Crlc281 nrlc281_2 rlc13 6.46793960196e-15
* RLC[283] rlc10-rlc15
Rrlc283 rlc10 nrlc283_1 81024.6620998
Lrlc283 nrlc283_1 nrlc283_2 0.146879503203
Crlc283 nrlc283_2 rlc15 3.58780807539e-06
* RLC[284] rlc10-P1B
Rrlc284 rlc10 nrlc284_1 8.62537880153
Lrlc284 nrlc284_1 nrlc284_2 3.16839652756e-08
Crlc284 nrlc284_2 P1B 4.73199795985e-13
* RLC[293] rlc12-P1B
Rrlc293 rlc12 nrlc293_1 0.033584132889
Lrlc293 nrlc293_1 nrlc293_2 4.53648227816e-10
Crlc293 nrlc293_2 P1B 1.61076154945e-09
* RLC[294] rlc13-rlc14
Rrlc294 rlc13 nrlc294_1 345.616061307
Lrlc294 nrlc294_1 nrlc294_2 2.71204826813e-06
Crlc294 nrlc294_2 rlc14 2.76412935712e-14
* RLC[295] rlc13-rlc15
Rrlc295 rlc13 nrlc295_1 0.632130050327
Lrlc295 nrlc295_1 nrlc295_2 1.50635904592e-06
Crlc295 nrlc295_2 rlc15 4.18864078896e-09
* RLC[299] rlc15-P1B
Rrlc299 rlc15 nrlc299_1 2004.15743611
Lrlc299 nrlc299_1 nrlc299_2 2.71993904512e-05
Crlc299 nrlc299_2 P1B 1.83396766964e-14
* DC[0] P1A-P2A
Rdc0 P1A ndc0_1 0.0296993420914
Ldc0 ndc0_1 P2A 5.53805583479e-08
* DC[23] P3A-P4A
Rdc23 P3A ndc23_1 0.162190138456
Ldc23 ndc23_1 P4A 6.76501265352e-08
* DC[42] P1B-P2B
Rdc42 P1B ndc42_1 9.9859681898
Ldc42 ndc42_1 P2B 4.30707335429e-06
* DC[43] P1B-P3B
Rdc43 P1B ndc43_1 5.41634524686
Ldc43 ndc43_1 P3B 1.18930904844e-06
* DC[46] P1B-dc1
Rdc46 P1B ndc46_1 0.16155933924
Ldc46 ndc46_1 dc1 7.4715591634e-08
* DC[50] P2B-P3B
Rdc50 P2B ndc50_1 2.341638697
Ldc50 ndc50_1 P3B 2.73851088765e-06
* DC[51] P2B-P4B
Rdc51 P2B ndc51_1 0.443947692914
Ldc51 ndc51_1 P4B 1.91605418575e-06
* DC[52] P2B-dc0
Rdc52 P2B ndc52_1 0.051638596574
Ldc52 ndc52_1 dc0 1.62146633692e-05
* DC[53] P2B-dc1
Rdc53 P2B ndc53_1 0.0250833750446
Ldc53 ndc53_1 dc1 5.21551263052e-09
* DC[54] P2B-dc2
Rdc54 P2B ndc54_1 0.0665957214883
Ldc54 ndc54_1 dc2 0.000344228516611
* DC[55] P2B-dc3
Rdc55 P2B ndc55_1 4.93310335556
Ldc55 ndc55_1 dc3 0.000205617442024
* DC[56] P2B-P1B
Rdc56 P2B ndc56_1 0.29510479589
Ldc56 ndc56_1 P1B 1.27245531222e-07
* DC[57] P3B-P4B
Rdc57 P3B ndc57_1 0.166997751142
Ldc57 ndc57_1 P4B 2.2454127556e-07
* DC[58] P3B-dc0
Rdc58 P3B ndc58_1 0.0698034460274
Ldc58 ndc58_1 dc0 1.60675378454e-07
* DC[59] P3B-dc1
Rdc59 P3B ndc59_1 0.280834644704
Ldc59 ndc59_1 dc1 1.32239327254e-05
* DC[60] P3B-dc2
Rdc60 P3B ndc60_1 0.268833358677
Ldc60 ndc60_1 dc2 1.34232088545e-06
* DC[61] P3B-dc3
Rdc61 P3B ndc61_1 0.0413554258908
Ldc61 ndc61_1 dc3 2.06935722103e-07
* DC[62] P3B-P1B
Rdc62 P3B ndc62_1 5.41635692486
Ldc62 ndc62_1 P1B 1.18931161843e-06
* DC[63] P4B-dc0
Rdc63 P4B ndc63_1 0.0648455210557
Ldc63 ndc63_1 dc0 4.20232931047e-08
* DC[64] P4B-dc1
Rdc64 P4B ndc64_1 0.0187021018202
Ldc64 ndc64_1 dc1 1.08963709583e-05
* DC[65] P4B-dc2
Rdc65 P4B ndc65_1 0.963732610389
Ldc65 ndc65_1 dc2 3.58813590492e-07
* DC[66] P4B-dc3
Rdc66 P4B ndc66_1 0.158134128347
Ldc66 ndc66_1 dc3 5.5751792698e-08
* DC[73] dc1-dc3
Rdc73 dc1 ndc73_1 88.1715433723
Ldc73 ndc73_1 dc3 3.17203347555e-05
* ---- leaks
Rleak_P1A P1A P1B 1e+12
Rleak_P2A P2A P1B 1e+12
Rleak_P2B P2B P1B 1e+12
Rleak_P3A P3A P1B 1e+12
Rleak_P3B P3B P1B 1e+12
Rleak_P4A P4A P1B 1e+12
Rleak_P4B P4B P1B 1e+12
Rleak_dc0 dc0 P1B 1e+12
Rleak_dc1 dc1 P1B 1e+12
Rleak_dc2 dc2 P1B 1e+12
Rleak_dc3 dc3 P1B 1e+12
Rleak_rlc0 rlc0 P1B 1e+12
Rleak_rlc1 rlc1 P1B 1e+12
Rleak_rlc10 rlc10 P1B 1e+12
Rleak_rlc11 rlc11 P1B 1e+12
Rleak_rlc12 rlc12 P1B 1e+12
Rleak_rlc13 rlc13 P1B 1e+12
Rleak_rlc14 rlc14 P1B 1e+12
Rleak_rlc15 rlc15 P1B 1e+12
Rleak_rlc2 rlc2 P1B 1e+12
Rleak_rlc3 rlc3 P1B 1e+12
Rleak_rlc4 rlc4 P1B 1e+12
Rleak_rlc5 rlc5 P1B 1e+12
Rleak_rlc6 rlc6 P1B 1e+12
Rleak_rlc7 rlc7 P1B 1e+12
Rleak_rlc8 rlc8 P1B 1e+12
Rleak_rlc9 rlc9 P1B 1e+12
.ends fitted
