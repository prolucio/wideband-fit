* fitted: 4-port fitted model, reference z0 = 50 Ohm
* port p is PpA (+) to PpB (-); the reference node is P1B
.subckt fitted P1A P1B P2A P2B P3A P3B P4A P4B
* ---- branches
* RLC[0] P1A-P2A
Rrlc0 P1A nrlc0_1 0.172755895056
Lrlc0 nrlc0_1 nrlc0_2 4.64484205865e-06
Crlc0 nrlc0_2 P2A 3.46994458855e-06
* RLC[1] P1A-P3A
Rrlc1 P1A nrlc1_1 33122.0737744
Lrlc1 nrlc1_1 nrlc1_2 0.000191573864811
Crlc1 nrlc1_2 P3A 6.26553486304e-15
* RLC[3] P1A-P1B
Rrlc3 P1A nrlc3_1 10.3740204757
Lrlc3 nrlc3_1 nrlc3_2 1.0680190887e-08
Crlc3 nrlc3_2 P1B 7.44559865456e-13
* RLC[5] P1A-P3B
Rrlc5 P1A nrlc5_1 781244.072385
Lrlc5 nrlc5_1 nrlc5_2 0.985587882554
Crlc5 nrlc5_2 P3B 3.7332284198e-11
* RLC[6] P1A-P4B
Rrlc6 P1A nrlc6_1 478.277235314
Lrlc6 nrlc6_1 nrlc6_2 7.29663438626e-14
Crlc6 nrlc6_2 P4B 3.29468228505e-14
* RLC[7] P1A-rlc0
Rrlc7 P1A nrlc7_1 182.912570068
Lrlc7 nrlc7_1 nrlc7_2 3.35874702309e-07
Crlc7 nrlc7_2 rlc0 1.11544465508e-14
* RLC[8] P1A-rlc1
Rrlc8 P1A nrlc8_1 525.087517977
Lrlc8 nrlc8_1 nrlc8_2 1.81093429298e-06
Crlc8 nrlc8_2 rlc1 7.29788128045e-15
* RLC[9] P1A-rlc2
Rrlc9 P1A nrlc9_1 9108.36080289
Lrlc9 nrlc9_1 nrlc9_2 0.000150922226425
Crlc9 nrlc9_2 rlc2 1.94169861201e-14
* RLC[11] P1A-rlc4
Rrlc11 P1A nrlc11_1 340.654068178
Lrlc11 nrlc11_1 nrlc11_2 1.60157555705e-15
Crlc11 nrlc11_2 rlc4 3.14146437889e-14
* RLC[12] P1A-rlc5
Rrlc12 P1A nrlc12_1 30.5743364558
Lrlc12 nrlc12_1 nrlc12_2 6.1887714984e-08
Crlc12 nrlc12_2 rlc5 7.35610394884e-14
* RLC[13] P1A-rlc6
Rrlc13 P1A nrlc13_1 9974.92481611
Lrlc13 nrlc13_1 nrlc13_2 3.57087914076e-06
Crlc13 nrlc13_2 rlc6 2.5034121208e-14
* RLC[14] P1A-rlc7
Rrlc14 P1A nrlc14_1 2.87788153203
Lrlc14 nrlc14_1 nrlc14_2 2.48119126345e-08
Crlc14 nrlc14_2 rlc7 3.32867894818e-12
* RLC[15] P1A-rlc8
Rrlc15 P1A nrlc15_1 191207.486157
Lrlc15 nrlc15_1 nrlc15_2 0.00714410186831
Crlc15 nrlc15_2 rlc8 8.29764750653e-12
* RLC[17] P1A-rlc10
Rrlc17 P1A nrlc17_1 14655.5737413
Lrlc17 nrlc17_1 nrlc17_2 0.000271830899543
Crlc17 nrlc17_2 rlc10 1.40621155685e-15
* RLC[18] P1A-rlc11
Rrlc18 P1A nrlc18_1 3156.27941615
Lrlc18 nrlc18_1 nrlc18_2 1.1196964958e-07
Crlc18 nrlc18_2 rlc11 6.68141243021e-15
* RLC[19] P1A-rlc12
Rrlc19 P1A nrlc19_1 2874.76554857
Lrlc19 nrlc19_1 nrlc19_2 5.49080122836e-06
Crlc19 nrlc19_2 rlc12 7.38227596231e-16
* RLC[20] P1A-rlc13
Rrlc20 P1A nrlc20_1 7.82879040246
Lrlc20 nrlc20_1 nrlc20_2 1.09923443897e-08
Crlc20 nrlc20_2 rlc13 1.99277742043e-13
* RLC[22] P1A-rlc15
Rrlc22 P1A nrlc22_1 249609.444428
Lrlc22 nrlc22_1 nrlc22_2 0.51013802186
Crlc22 nrlc22_2 rlc15 6.03702389368e-05
* RLC[24] P2A-P3A
Rrlc24 P2A nrlc24_1 1312.37188406
Lrlc24 nrlc24_1 nrlc24_2 5.15669254958e-15
Crlc24 nrlc24_2 P3A 2.63035908077e-14
* RLC[25] P2A-P4A
Rrlc25 P2A nrlc25_1 11951.475826
Lrlc25 nrlc25_1 nrlc25_2 0.000224569398256
Crlc25 nrlc25_2 P4A 3.88286952456e-15
* RLC[26] P2A-P1B
Rrlc26 P2A nrlc26_1 0.87688819386
Lrlc26 nrlc26_1 nrlc26_2 1.42257684799e-09
Crlc26 nrlc26_2 P1B 4.61773188757e-12
* RLC[27] P2A-P2B
Rrlc27 P2A nrlc27_1 362239.860786
Lrlc27 nrlc27_1 nrlc27_2 0.00571288003958
Crlc27 nrlc27_2 P2B 1.57380134278e-13
* RLC[29] P2A-P4B
Rrlc29 P2A nrlc29_1 120078.490848
Lrlc29 nrlc29_1 nrlc29_2 0.000888910304111
Crlc29 nrlc29_2 P4B 4.44412165136e-15
* RLC[32] P2A-rlc2
Rrlc32 P2A nrlc32_1 1167368.071
Lrlc32 nrlc32_1 nrlc32_2 1
Crlc32 nrlc32_2 rlc2 2.45882306506e-11
* RLC[33] P2A-rlc3
Rrlc33 P2A nrlc33_1 29042.1007958
Lrlc33 nrlc33_1 nrlc33_2 5.81678992036e-05
Crlc33 nrlc33_2 rlc3 3.04005982806e-13
* RLC[34] P2A-rlc4
Rrlc34 P2A nrlc34_1 34519.2200435
Lrlc34 nrlc34_1 nrlc34_2 9.70261080021e-06
Crlc34 nrlc34_2 rlc4 2.70940497776e-14
* RLC[36] P2A-rlc6
Rrlc36 P2A nrlc36_1 2512682.12648
Lrlc36 nrlc36_1 nrlc36_2 0.000221911521208
Crlc36 nrlc36_2 rlc6 1.56474259951e-13
* RLC[37] P2A-rlc7
Rrlc37 P2A nrlc37_1 0.990769154202
Lrlc37 nrlc37_1 nrlc37_2 2.90890363522e-09
Crlc37 nrlc37_2 rlc7 3.29262196202e-12
* RLC[38] P2A-rlc8
Rrlc38 P2A nrlc38_1 0.253413101627
Lrlc38 nrlc38_1 nrlc38_2 4.29587621142e-13
Crlc38 nrlc38_2 rlc8 1.09326243681e-14
* RLC[40] P2A-rlc10
Rrlc40 P2A nrlc40_1 1158.28495225
Lrlc40 nrlc40_1 nrlc40_2 1.95850673674e-06
Crlc40 nrlc40_2 rlc10 4.12799801705e-15
* RLC[41] P2A-rlc11
Rrlc41 P2A nrlc41_1 4759363.46446
Lrlc41 nrlc41_1 nrlc41_2 7.45471750281e-07
Crlc41 nrlc41_2 rlc11 1.94189976213e-12
* RLC[42] P2A-rlc12
Rrlc42 P2A nrlc42_1 6437.56205102
Lrlc42 nrlc42_1 nrlc42_2 4.98290514828e-06
Crlc42 nrlc42_2 rlc12 3.00734539211e-15
* RLC[43] P2A-rlc13
Rrlc43 P2A nrlc43_1 9815.50871924
Lrlc43 nrlc43_1 nrlc43_2 3.83179922408e-06
Crlc43 nrlc43_2 rlc13 1.28838337699e-13
* RLC[45] P2A-rlc15
Rrlc45 P2A nrlc45_1 2162.73685593
Lrlc45 nrlc45_1 nrlc45_2 1.23724804441e-05
Crlc45 nrlc45_2 rlc15 2.93904952348e-15
* RLC[46] P2A-P1B
Rrlc46 P2A nrlc46_1 187.158727192
Lrlc46 nrlc46_1 nrlc46_2 2.10465902758e-07
Crlc46 nrlc46_2 P1B 1.77012232298e-13
* RLC[49] P3A-P2B
Rrlc49 P3A nrlc49_1 206.923848695
Lrlc49 nrlc49_1 nrlc49_2 5.77306311885e-07
Crlc49 nrlc49_2 P2B 1.49810654493e-14
* RLC[51] P3A-P4B
Rrlc51 P3A nrlc51_1 1.02783542944
Lrlc51 nrlc51_1 nrlc51_2 9.81469045366e-09
Crlc51 nrlc51_2 P4B 1.03225484516e-11
* RLC[57] P3A-rlc5
Rrlc57 P3A nrlc57_1 6.55632357414
Lrlc57 nrlc57_1 nrlc57_2 1.67108427528e-08
Crlc57 nrlc57_2 rlc5 4.31951597803e-13
* RLC[59] P3A-rlc7
Rrlc59 P3A nrlc59_1 687.909412967
Lrlc59 nrlc59_1 nrlc59_2 2.84610780197e-06
Crlc59 nrlc59_2 rlc7 6.68261332162e-15
* RLC[63] P3A-rlc11
Rrlc63 P3A nrlc63_1 312058.120716
Lrlc63 nrlc63_1 nrlc63_2 0.286956876588
Crlc63 nrlc63_2 rlc11 2.65771921134e-11
* RLC[65] P3A-rlc13
Rrlc65 P3A nrlc65_1 743.09382359
Lrlc65 nrlc65_1 nrlc65_2 1.7675882928e-06
Crlc65 nrlc65_2 rlc13 3.5567333232e-15
* RLC[73] P4A-rlc0
Rrlc73 P4A nrlc73_1 1201.42206949
Lrlc73 nrlc73_1 nrlc73_2 1.98938576156e-05
Crlc73 nrlc73_2 rlc0 1.53138815982e-14
* RLC[77] P4A-rlc4
Rrlc77 P4A nrlc77_1 0.826601899841
Lrlc77 nrlc77_1 nrlc77_2 4.99113456638e-09
Crlc77 nrlc77_2 rlc4 8.1164098901e-12
* RLC[78] P4A-rlc5
Rrlc78 P4A nrlc78_1 14.8954906351
Lrlc78 nrlc78_1 nrlc78_2 2.30529084386e-07
Crlc78 nrlc78_2 rlc5 1.15444591232e-12
* RLC[79] P4A-rlc6
Rrlc79 P4A nrlc79_1 82.349096114
Lrlc79 nrlc79_1 nrlc79_2 2.68654734612e-07
Crlc79 nrlc79_2 rlc6 4.40184064368e-14
* RLC[80] P4A-rlc7
Rrlc80 P4A nrlc80_1 1326924.0116
Lrlc80 nrlc80_1 nrlc80_2 0.0406434602576
Crlc80 nrlc80_2 rlc7 2.61536904227e-13
* RLC[83] P4A-rlc10
Rrlc83 P4A nrlc83_1 62496.6134644
Lrlc83 nrlc83_1 nrlc83_2 1
Crlc83 nrlc83_2 rlc10 0.001
* RLC[84] P4A-rlc11
Rrlc84 P4A nrlc84_1 391576.657293
Lrlc84 nrlc84_1 nrlc84_2 0.0145487421894
Crlc84 nrlc84_2 rlc11 8.10801083907e-14
* RLC[85] P4A-rlc12
Rrlc85 P4A nrlc85_1 695.128788315
Lrlc85 nrlc85_1 nrlc85_2 8.26172713297e-06
Crlc85 nrlc85_2 rlc12 1.89975583811e-14
* RLC[86] P4A-rlc13
Rrlc86 P4A nrlc86_1 109192.967842
Lrlc86 nrlc86_1 nrlc86_2 0.00107709284292
Crlc86 nrlc86_2 rlc13 1.19647619743e-11
* RLC[91] P1B-P3B
Rrlc91 P1B nrlc91_1 12551.4652468
Lrlc91 nrlc91_1 nrlc91_2 2.82540892892e-11
Crlc91 nrlc91_2 P3B 1.34545558815e-11
* RLC[96] P1B-rlc3
Rrlc96 P1B nrlc96_1 496.968835955
Lrlc96 nrlc96_1 nrlc96_2 1.50254571827e-05
Crlc96 nrlc96_2 rlc3 6.75969147411e-14
* RLC[98] P1B-rlc5
Rrlc98 P1B nrlc98_1 2959.1897438
Lrlc98 nrlc98_1 nrlc98_2 3.93593315878e-05
Crlc98 nrlc98_2 rlc5 5.29467847712e-13
* RLC[99] P1B-rlc6
Rrlc99 P1B nrlc99_1 0.0359017895775
Lrlc99 nrlc99_1 nrlc99_2 1.82306573728e-07
Crlc99 nrlc99_2 rlc6 3.15286330655e-05
* RLC[102] P1B-rlc9
Rrlc102 P1B nrlc102_1 237.999382334
Lrlc102 nrlc102_1 nrlc102_2 4.6014633553e-07
Crlc102 nrlc102_2 rlc9 4.30122920105e-14
* RLC[104] P1B-rlc11
Rrlc104 P1B nrlc104_1 2402.63002892
Lrlc104 nrlc104_1 nrlc104_2 1.79209913327e-05
Crlc104 nrlc104_2 rlc11 3.44941715471e-15
* RLC[105] P1B-rlc12
Rrlc105 P1B nrlc105_1 772.900810349
Lrlc105 nrlc105_1 nrlc105_2 6.28419804561e-06
Crlc105 nrlc105_2 rlc12 1.16885281902e-14
* RLC[106] P1B-rlc13
Rrlc106 P1B nrlc106_1 731.833882018
Lrlc106 nrlc106_1 nrlc106_2 5.98351663257e-06
Crlc106 nrlc106_2 rlc13 2.93369512873e-14
* RLC[108] P1B-rlc15
Rrlc108 P1B nrlc108_1 353.820676912
Lrlc108 nrlc108_1 nrlc108_2 1.40180043293e-05
Crlc108 nrlc108_2 rlc15 7.47398488119e-11
* RLC[110] P2B-P3B
Rrlc110 P2B nrlc110_1 595.838891027
Lrlc110 nrlc110_1 nrlc110_2 2.12752994951e-06
Crlc110 nrlc110_2 P3B 1.9874370453e-12
* RLC[111] P2B-P4B
Rrlc111 P2B nrlc111_1 11.6563073733
Lrlc111 nrlc111_1 nrlc111_2 1.70289974862e-06
Crlc111 nrlc111_2 P4B 5.24957994237e-08
* RLC[112] P2B-rlc0
Rrlc112 P2B nrlc112_1 1.55020607777
Lrlc112 nrlc112_1 nrlc112_2 6.18673626172e-06
Crlc112 nrlc112_2 rlc0 8.82378836473e-07
* RLC[114] P2B-rlc2
Rrlc114 P2B nrlc114_1 1150.1772967
Lrlc114 nrlc114_1 nrlc114_2 4.83978117741e-06
Crlc114 nrlc114_2 rlc2 4.06493527766e-15
* RLC[115] P2B-rlc3
Rrlc115 P2B nrlc115_1 32.8374906123
Lrlc115 nrlc115_1 nrlc115_2 5.87950967734e-08
Crlc115 nrlc115_2 rlc3 2.56801669584e-13
* RLC[116] P2B-rlc4
Rrlc116 P2B nrlc116_1 15587.7631439
Lrlc116 nrlc116_1 nrlc116_2 3.14650254196e-05
Crlc116 nrlc116_2 rlc4 1.66858564092e-14
* RLC[118] P2B-rlc6
Rrlc118 P2B nrlc118_1 0.473332405365
Lrlc118 nrlc118_1 nrlc118_2 4.16526550335e-07
Crlc118 nrlc118_2 rlc6 0.000459000868367
* RLC[119] P2B-rlc7
Rrlc119 P2B nrlc119_1 0.025549499267
Lrlc119 nrlc119_1 nrlc119_2 1.78340665805e-08
Crlc119 nrlc119_2 rlc7 0.000486634404987
* RLC[120] P2B-rlc8
Rrlc120 P2B nrlc120_1 42.0848350613
Lrlc120 nrlc120_1 nrlc120_2 6.20325408574e-06
Crlc120 nrlc120_2 rlc8 5.89126254899e-08
* RLC[121] P2B-rlc9
Rrlc121 P2B nrlc121_1 0.01564603633
Lrlc121 nrlc121_1 nrlc121_2 4.43384523521e-07
Crlc121 nrlc121_2 rlc9 0.001
* RLC[124] P2B-rlc12
Rrlc124 P2B nrlc124_1 2517.93287173
Lrlc124 nrlc124_1 nrlc124_2 2.02120691262e-05
Crlc124 nrlc124_2 rlc12 3.54225620909e-15
* RLC[125] P2B-rlc13
Rrlc125 P2B nrlc125_1 808.481440814
Lrlc125 nrlc125_1 nrlc125_2 1.65951097042e-05
Crlc125 nrlc125_2 rlc13 8.34834416694e-12
* RLC[128] P2B-P1B
Rrlc128 P2B nrlc128_1 2.63519917163
Lrlc128 nrlc128_1 nrlc128_2 7.6176560694e-09
Crlc128 nrlc128_2 P1B 1.21885476835e-12
* RLC[129] P3B-P4B
Rrlc129 P3B nrlc129_1 992.443267719
Lrlc129 nrlc129_1 nrlc129_2 9.21184462155e-06
Crlc129 nrlc129_2 P4B 1.03918462955e-14
* RLC[131] P3B-rlc1
Rrlc131 P3B nrlc131_1 0.01
Lrlc131 nrlc131_1 nrlc131_2 2.17721850248e-15
Crlc131 nrlc131_2 rlc1 3.49662460617e-12
* RLC[132] P3B-rlc2
Rrlc132 P3B nrlc132_1 7.54563482168
Lrlc132 nrlc132_1 nrlc132_2 1.36342926194e-08
Crlc132 nrlc132_2 rlc2 2.66071608207e-13
* RLC[135] P3B-rlc5
Rrlc135 P3B nrlc135_1 8973.58617351
Lrlc135 nrlc135_1 nrlc135_2 0.00578171492005
Crlc135 nrlc135_2 rlc5 1.53967988912e-10
* RLC[137] P3B-rlc7
Rrlc137 P3B nrlc137_1 68.6667680348
Lrlc137 nrlc137_1 nrlc137_2 1.91339123993e-06
Crlc137 nrlc137_2 rlc7 4.50887357599e-13
* RLC[138] P3B-rlc8
Rrlc138 P3B nrlc138_1 19.5111959791
Lrlc138 nrlc138_1 nrlc138_2 2.22842724676e-07
Crlc138 nrlc138_2 rlc8 9.08983638076e-11
* RLC[139] P3B-rlc9
Rrlc139 P3B nrlc139_1 0.402640406261
Lrlc139 nrlc139_1 nrlc139_2 2.81145704728e-08
Crlc139 nrlc139_2 rlc9 1.92687806214e-10
* RLC[140] P3B-rlc10
Rrlc140 P3B nrlc140_1 1.05160238832
Lrlc140 nrlc140_1 nrlc140_2 4.0703630092e-08
Crlc140 nrlc140_2 rlc10 4.08966284463e-11
* RLC[141] P3B-rlc11
Rrlc141 P3B nrlc141_1 0.01
Lrlc141 nrlc141_1 nrlc141_2 8.88296753734e-08
Crlc141 nrlc141_2 rlc11 5.30229229556e-05
* RLC[142] P3B-rlc12
Rrlc142 P3B nrlc142_1 7.75373037423
Lrlc142 nrlc142_1 nrlc142_2 2.32274024577e-08
Crlc142 nrlc142_2 rlc12 4.29276135517e-13
* RLC[143] P3B-rlc13
Rrlc143 P3B nrlc143_1 23524.6014743
Lrlc143 nrlc143_1 nrlc143_2 0.000276926213044
Crlc143 nrlc143_2 rlc13 5.56002837037e-16
* RLC[144] P3B-rlc14
Rrlc144 P3B nrlc144_1 8.16125575056
Lrlc144 nrlc144_1 nrlc144_2 3.31508759479e-08
Crlc144 nrlc144_2 rlc14 5.53017053066e-13
* RLC[146] P3B-P1B
Rrlc146 P3B nrlc146_1 9.8810644065
Lrlc146 nrlc146_1 nrlc146_2 1.68269984716e-06
Crlc146 nrlc146_2 P1B 6.01215542626e-08
* RLC[152] P4B-rlc5
Rrlc152 P4B nrlc152_1 0.0534517106693
Lrlc152 nrlc152_1 nrlc152_2 0.00257137683612
Crlc152 nrlc152_2 rlc5 0.001
* RLC[154] P4B-rlc7
Rrlc154 P4B nrlc154_1 3001.77304208
Lrlc154 nrlc154_1 nrlc154_2 2.13353172832e-05
Crlc154 nrlc154_2 rlc7 3.07212288898e-13
* RLC[156] P4B-rlc9
Rrlc156 P4B nrlc156_1 0.01
Lrlc156 nrlc156_1 nrlc156_2 5.41140091439e-16
Crlc156 nrlc156_2 rlc9 7.63294124549e-12
* RLC[158] P4B-rlc11
Rrlc158 P4B nrlc158_1 2.82308674888
Lrlc158 nrlc158_1 nrlc158_2 5.39605883011e-07
Crlc158 nrlc158_2 rlc11 0.001
* RLC[161] P4B-rlc14
Rrlc161 P4B nrlc161_1 1075.07673342
Lrlc161 nrlc161_1 nrlc161_2 5.4984605004e-06
Crlc161 nrlc161_2 rlc14 5.28590889973e-15
* RLC[162] P4B-rlc15
Rrlc162 P4B nrlc162_1 28788.6791018
Lrlc162 nrlc162_1 nrlc162_2 0.00174282233157
Crlc162 nrlc162_2 rlc15 1.137379548e-09
* RLC[163] P4B-P1B
Rrlc163 P4B nrlc163_1 1573.77606236
Lrlc163 nrlc163_1 nrlc163_2 4.09878347442e-06
Crlc163 nrlc163_2 P1B 1.83876655807e-15
* RLC[164] rlc0-rlc1
Rrlc164 rlc0 nrlc164_1 0.01
Lrlc164 nrlc164_1 nrlc164_2 4.75131495642e-08
Crlc164 nrlc164_2 rlc1 3.20820194299e-05
* RLC[165] rlc0-rlc2
Rrlc165 rlc0 nrlc165_1 684.969061181
Lrlc165 nrlc165_1 nrlc165_2 3.21829061097e-05
Crlc165 nrlc165_2 rlc2 7.62150673111e-14
* RLC[166] rlc0-rlc3
Rrlc166 rlc0 nrlc166_1 0.01
Lrlc166 nrlc166_1 nrlc166_2 2.32179623359e-11
Crlc166 nrlc166_2 rlc3 0.001
* RLC[168] rlc0-rlc5
Rrlc168 rlc0 nrlc168_1 317.240869759
Lrlc168 nrlc168_1 nrlc168_2 9.68450204046e-07
Crlc168 nrlc168_2 rlc5 2.05730923955e-12
* RLC[170] rlc0-rlc7
Rrlc170 rlc0 nrlc170_1 1279.24512113
Lrlc170 nrlc170_1 nrlc170_2 5.28276072781e-06
Crlc170 nrlc170_2 rlc7 3.5945537507e-14
* RLC[171] rlc0-rlc8
Rrlc171 rlc0 nrlc171_1 3.89907657496
Lrlc171 nrlc171_1 nrlc171_2 6.15521684122e-08
Crlc171 nrlc171_2 rlc8 4.49859937741e-12
* RLC[174] rlc0-rlc11
Rrlc174 rlc0 nrlc174_1 32.1416406889
Lrlc174 nrlc174_1 nrlc174_2 2.94235635746e-07
Crlc174 nrlc174_2 rlc11 2.66006416868e-09
* RLC[177] rlc0-rlc14
Rrlc177 rlc0 nrlc177_1 32.769220071
Lrlc177 nrlc177_1 nrlc177_2 7.83375155881e-08
Crlc177 nrlc177_2 rlc14 8.58624512481e-13
* RLC[178] rlc0-rlc15
Rrlc178 rlc0 nrlc178_1 264.691504589
Lrlc178 nrlc178_1 nrlc178_2 2.46179800492e-06
Crlc178 nrlc178_2 rlc15 3.90418061454e-14
* RLC[179] rlc0-P1B
Rrlc179 rlc0 nrlc179_1 0.103807328433
Lrlc179 nrlc179_1 nrlc179_2 1.24294857116e-07
Crlc179 nrlc179_2 P1B 0.000972089274586
* RLC[180] rlc1-rlc2
Rrlc180 rlc1 nrlc180_1 455.393467416
Lrlc180 nrlc180_1 nrlc180_2 1.03875558908e-05
Crlc180 nrlc180_2 rlc2 5.56541137462e-14
* RLC[181] rlc1-rlc3
Rrlc181 rlc1 nrlc181_1 77.1444470523
Lrlc181 nrlc181_1 nrlc181_2 8.89765472175e-07
Crlc181 nrlc181_2 rlc3 1.66120679268e-13
* RLC[182] rlc1-rlc4
Rrlc182 rlc1 nrlc182_1 1.32061104322
Lrlc182 nrlc182_1 nrlc182_2 4.27951589035e-09
Crlc182 nrlc182_2 rlc4 2.72647980135e-12
* RLC[184] rlc1-rlc6
Rrlc184 rlc1 nrlc184_1 4.11076887544
Lrlc184 nrlc184_1 nrlc184_2 1.18876869168e-08
Crlc184 nrlc184_2 rlc6 7.8164351665e-13
* RLC[185] rlc1-rlc7
Rrlc185 rlc1 nrlc185_1 292.163053069
Lrlc185 nrlc185_1 nrlc185_2 9.03603191473e-06
Crlc185 nrlc185_2 rlc7 8.61364640157e-13
* RLC[187] rlc1-rlc9
Rrlc187 rlc1 nrlc187_1 173.218731219
Lrlc187 nrlc187_1 nrlc187_2 7.22298166464e-07
Crlc187 nrlc187_2 rlc9 2.67475677728e-14
* RLC[188] rlc1-rlc10
Rrlc188 rlc1 nrlc188_1 307.638162297
Lrlc188 nrlc188_1 nrlc188_2 2.43722046874e-06
Crlc188 nrlc188_2 rlc10 2.86135597385e-14
* RLC[189] rlc1-rlc11
Rrlc189 rlc1 nrlc189_1 48.8913176088
Lrlc189 nrlc189_1 nrlc189_2 8.01202810401e-07
Crlc189 nrlc189_2 rlc11 5.19958093786e-11
* RLC[191] rlc1-rlc13
Rrlc191 rlc1 nrlc191_1 161.709145545
Lrlc191 nrlc191_1 nrlc191_2 8.58747539861e-06
Crlc191 nrlc191_2 rlc13 3.64883169566e-13
* RLC[192] rlc1-rlc14
Rrlc192 rlc1 nrlc192_1 26.7080628126
Lrlc192 nrlc192_1 nrlc192_2 9.31109562859e-07
Crlc192 nrlc192_2 rlc14 3.28169430184e-12
* RLC[193] rlc1-rlc15
Rrlc193 rlc1 nrlc193_1 12.3986977641
Lrlc193 nrlc193_1 nrlc193_2 8.21067170062e-08
Crlc193 nrlc193_2 rlc15 5.93449858785e-13
* RLC[195] rlc2-rlc3
Rrlc195 rlc2 nrlc195_1 14.9054714676
Lrlc195 nrlc195_1 nrlc195_2 7.40603258825e-06
Crlc195 nrlc195_2 rlc3 7.83536311382e-09
* RLC[196] rlc2-rlc4
Rrlc196 rlc2 nrlc196_1 39.7139245635
Lrlc196 nrlc196_1 nrlc196_2 2.4457825679e-07
Crlc196 nrlc196_2 rlc4 1.72301763627e-13
* RLC[199] rlc2-rlc7
Rrlc199 rlc2 nrlc199_1 348.318486843
Lrlc199 nrlc199_1 nrlc199_2 9.9297837271e-06
Crlc199 nrlc199_2 rlc7 2.41119450214e-12
* RLC[201] rlc2-rlc9
Rrlc201 rlc2 nrlc201_1 0.090339803499
Lrlc201 nrlc201_1 nrlc201_2 3.85553308438e-07
Crlc201 nrlc201_2 rlc9 5.24908543611e-08
* RLC[204] rlc2-rlc12
Rrlc204 rlc2 nrlc204_1 200.962643972
Lrlc204 nrlc204_1 nrlc204_2 1.47790960148e-05
Crlc204 nrlc204_2 rlc12 4.0660684864e-13
* RLC[205] rlc2-rlc13
Rrlc205 rlc2 nrlc205_1 856.651448482
Lrlc205 nrlc205_1 nrlc205_2 5.28124256193e-05
Crlc205 nrlc205_2 rlc13 1.23490286189e-13
* RLC[206] rlc2-rlc14
Rrlc206 rlc2 nrlc206_1 0.01
Lrlc206 nrlc206_1 nrlc206_2 5.68735409562e-07
Crlc206 nrlc206_2 rlc14 8.67896167417e-06
* RLC[209] rlc3-rlc4
Rrlc209 rlc3 nrlc209_1 160.67235488
Lrlc209 nrlc209_1 nrlc209_2 6.66687968455e-07
Crlc209 nrlc209_2 rlc4 2.86944424324e-14
* RLC[211] rlc3-rlc6
Rrlc211 rlc3 nrlc211_1 116.43758474
Lrlc211 nrlc211_1 nrlc211_2 3.46587809364e-06
Crlc211 nrlc211_2 rlc6 4.79309665669e-13
* RLC[212] rlc3-rlc7
Rrlc212 rlc3 nrlc212_1 232.96319144
Lrlc212 nrlc212_1 nrlc212_2 5.20788423233e-06
Crlc212 nrlc212_2 rlc7 1.06621355064e-13
* RLC[213] rlc3-rlc8
Rrlc213 rlc3 nrlc213_1 0.01
Lrlc213 nrlc213_1 nrlc213_2 1.03318891852e-14
Crlc213 nrlc213_2 rlc8 2.95310966531e-11
* RLC[214] rlc3-rlc9
Rrlc214 rlc3 nrlc214_1 0.01
Lrlc214 nrlc214_1 nrlc214_2 4.5013927841e-11
Crlc214 nrlc214_2 rlc9 0.001
* RLC[216] rlc3-rlc11
Rrlc216 rlc3 nrlc216_1 125.831200729
Lrlc216 nrlc216_1 nrlc216_2 4.84574794905e-07
Crlc216 nrlc216_2 rlc11 3.40049099829e-14
* RLC[217] rlc3-rlc12
Rrlc217 rlc3 nrlc217_1 0.948973043068
Lrlc217 nrlc217_1 nrlc217_2 1.06016704132e-08
Crlc217 nrlc217_2 rlc12 1.30804907351e-11
* RLC[218] rlc3-rlc13
Rrlc218 rlc3 nrlc218_1 50.0276724615
Lrlc218 nrlc218_1 nrlc218_2 4.60597838841e-07
Crlc218 nrlc218_2 rlc13 2.04483745219e-13
* RLC[219] rlc3-rlc14
Rrlc219 rlc3 nrlc219_1 0.0179334440339
Lrlc219 nrlc219_1 nrlc219_2 1.83670972896e-12
Crlc219 nrlc219_2 rlc14 6.34556962158e-12
* RLC[224] rlc4-rlc7
Rrlc224 rlc4 nrlc224_1 0.682258244815
Lrlc224 nrlc224_1 nrlc224_2 5.45942276286e-07
Crlc224 nrlc224_2 rlc7 0.000609057554255
* RLC[225] rlc4-rlc8
Rrlc225 rlc4 nrlc225_1 0.0296443885644
Lrlc225 nrlc225_1 nrlc225_2 6.06394988293e-08
Crlc225 nrlc225_2 rlc8 7.66704654107e-08
* RLC[226] rlc4-rlc9
Rrlc226 rlc4 nrlc226_1 0.258823106851
Lrlc226 nrlc226_1 nrlc226_2 4.00482731594e-08
Crlc226 nrlc226_2 rlc9 6.6425555182e-10
* RLC[230] rlc4-rlc13
Rrlc230 rlc4 nrlc230_1 16108.0420417
Lrlc230 nrlc230_1 nrlc230_2 0.000387362553056
Crlc230 nrlc230_2 rlc13 5.32700455419e-11
* RLC[232] rlc4-rlc15
Rrlc232 rlc4 nrlc232_1 44.7184584124
Lrlc232 nrlc232_1 nrlc232_2 1.66512552047e-07
Crlc232 nrlc232_2 rlc15 9.25189766428e-14
* RLC[233] rlc4-P1B
Rrlc233 rlc4 nrlc233_1 0.132525758776
Lrlc233 nrlc233_1 nrlc233_2 4.99696835522e-07
Crlc233 nrlc233_2 P1B 3.3289524333e-05
* RLC[234] rlc5-rlc6
Rrlc234 rlc5 nrlc234_1 137.483643609
Lrlc234 nrlc234_1 nrlc234_2 1.3521158874e-06
Crlc234 nrlc234_2 rlc6 7.94821012006e-14
* RLC[236] rlc5-rlc8
Rrlc236 rlc5 nrlc236_1 2142.47516121
Lrlc236 nrlc236_1 nrlc236_2 6.3119055866e-05
Crlc236 nrlc236_2 rlc8 4.56148363236e-10
* RLC[238] rlc5-rlc10
Rrlc238 rlc5 nrlc238_1 23988.0615697
Lrlc238 nrlc238_1 nrlc238_2 0.288202023259
Crlc238 nrlc238_2 rlc10 9.8749163177e-12
* RLC[239] rlc5-rlc11
Rrlc239 rlc5 nrlc239_1 2.11197248508
Lrlc239 nrlc239_1 nrlc239_2 2.96027729347e-08
Crlc239 nrlc239_2 rlc11 7.37417386099e-12
* RLC[241] rlc5-rlc13
Rrlc241 rlc5 nrlc241_1 172.449295689
Lrlc241 nrlc241_1 nrlc241_2 8.18434004467e-07
Crlc241 nrlc241_2 rlc13 0.001
* RLC[242] rlc5-rlc14
Rrlc242 rlc5 nrlc242_1 5.02491676297
Lrlc242 nrlc242_1 nrlc242_2 3.2496701658e-08
Crlc242 nrlc242_2 rlc14 1.43000985227e-12
* RLC[245] rlc6-rlc7
Rrlc245 rlc6 nrlc245_1 1217.4578733
Lrlc245 nrlc245_1 nrlc245_2 1.53281718978e-07
Crlc245 nrlc245_2 rlc7 1.77058994562e-14
* RLC[246] rlc6-rlc8
Rrlc246 rlc6 nrlc246_1 34.8499791038
Lrlc246 nrlc246_1 nrlc246_2 3.15753677522e-07
Crlc246 nrlc246_2 rlc8 3.66269116432e-10
* RLC[247] rlc6-rlc9
Rrlc247 rlc6 nrlc247_1 3.23728378283
Lrlc247 nrlc247_1 nrlc247_2 2.39018901167e-07
Crlc247 nrlc247_2 rlc9 8.8211648382e-07
* RLC[248] rlc6-rlc10
Rrlc248 rlc6 nrlc248_1 0.287874093254
Lrlc248 nrlc248_1 nrlc248_2 9.87198346423e-09
Crlc248 nrlc248_2 rlc10 1.32359995503e-10
* RLC[249] rlc6-rlc11
Rrlc249 rlc6 nrlc249_1 78.0067024435
Lrlc249 nrlc249_1 nrlc249_2 9.77107197808e-07
Crlc249 nrlc249_2 rlc11 1.78416848606e-13
* RLC[250] rlc6-rlc12
Rrlc250 rlc6 nrlc250_1 1.2139357629
Lrlc250 nrlc250_1 nrlc250_2 5.88258433851e-08
Crlc250 nrlc250_2 rlc12 4.43541479525e-11
* RLC[251] rlc6-rlc13
Rrlc251 rlc6 nrlc251_1 308.180479222
Lrlc251 nrlc251_1 nrlc251_2 7.64627023734e-06
Crlc251 nrlc251_2 rlc13 8.9453405983e-14
* RLC[252] rlc6-rlc14
Rrlc252 rlc6 nrlc252_1 292.119531175
Lrlc252 nrlc252_1 nrlc252_2 2.09735860488e-05
Crlc252 nrlc252_2 rlc14 3.83039339049e-13
* RLC[253] rlc6-rlc15
Rrlc253 rlc6 nrlc253_1 7775.04326538
Lrlc253 nrlc253_1 nrlc253_2 9.56277541287e-05
Crlc253 nrlc253_2 rlc15 1.56900461113e-09
* RLC[255] rlc7-rlc8
Rrlc255 rlc7 nrlc255_1 1080.15314243
Lrlc255 nrlc255_1 nrlc255_2 3.96348614699e-05
Crlc255 nrlc255_2 rlc8 9.71865838428e-12
* RLC[256] rlc7-rlc9
Rrlc256 rlc7 nrlc256_1 0.209376335994
Lrlc256 nrlc256_1 nrlc256_2 2.15075456473e-07
Crlc256 nrlc256_2 rlc9 1.9241496218e-05
* RLC[257] rlc7-rlc10
Rrlc257 rlc7 nrlc257_1 205.641423358
Lrlc257 nrlc257_1 nrlc257_2 5.54093370956e-06
Crlc257 nrlc257_2 rlc10 1.45585875523e-13
* RLC[258] rlc7-rlc11
Rrlc258 rlc7 nrlc258_1 1153.67529843
Lrlc258 nrlc258_1 nrlc258_2 8.28875836076e-06
Crlc258 nrlc258_2 rlc11 1.55830310931e-14
* RLC[259] rlc7-rlc12
Rrlc259 rlc7 nrlc259_1 12843.0485475
Lrlc259 nrlc259_1 nrlc259_2 0.000223492376901
Crlc259 nrlc259_2 rlc12 1.50551108139e-15
* RLC[261] rlc7-rlc14
Rrlc261 rlc7 nrlc261_1 5.64822761603
Lrlc261 nrlc261_1 nrlc261_2 6.98551944149e-07
Crlc261 nrlc261_2 rlc14 6.04697391084e-06
* RLC[262] rlc7-rlc15
Rrlc262 rlc7 nrlc262_1 41580.7967634
Lrlc262 nrlc262_1 nrlc262_2 4.0867653501e-05
Crlc262 nrlc262_2 rlc15 1.36048150751e-15
* RLC[263] rlc7-P1B
Rrlc263 rlc7 nrlc263_1 0.184046764725
Lrlc263 nrlc263_1 nrlc263_2 4.37960500992e-08
Crlc263 nrlc263_2 P1B 8.19674621487e-06
* RLC[265] rlc8-rlc10
Rrlc265 rlc8 nrlc265_1 0.942687394066
Lrlc265 nrlc265_1 nrlc265_2 2.4972683277e-08
Crlc265 nrlc265_2 rlc10 3.12239110113e-11
* RLC[266] rlc8-rlc11
Rrlc266 rlc8 nrlc266_1 9.30153950579
Lrlc266 nrlc266_1 nrlc266_2 2.24974139181e-07
Crlc266 nrlc266_2 rlc11 2.88921871531e-12
* RLC[267] rlc8-rlc12
Rrlc267 rlc8 nrlc267_1 27.3483715502
Lrlc267 nrlc267_1 nrlc267_2 7.43634456541e-07
Crlc267 nrlc267_2 rlc12 1.24465161752e-10
* RLC[268] rlc8-rlc13
Rrlc268 rlc8 nrlc268_1 6.83801648342
Lrlc268 nrlc268_1 nrlc268_2 1.98280725595e-07
Crlc268 nrlc268_2 rlc13 4.71170078972e-12
* RLC[269] rlc8-rlc14
Rrlc269 rlc8 nrlc269_1 7.6693507203
Lrlc269 nrlc269_1 nrlc269_2 1.35479108957e-08
Crlc269 nrlc269_2 rlc14 2.55924948802e-13
* RLC[273] rlc9-rlc11
Rrlc273 rlc9 nrlc273_1 130.20395653
Lrlc273 nrlc273_1 nrlc273_2 1.07586457541e-06
Crlc273 nrlc273_2 rlc11 7.05126011338e-14
* RLC[274] rlc9-rlc12
Rrlc274 rlc9 nrlc274_1 68.9720848615
Lrlc274 nrlc274_1 nrlc274_2 2.59627927216e-06
Crlc274 nrlc274_2 rlc12 6.06404183688e-13
* RLC[275] rlc9-rlc13
Rrlc275 rlc9 nrlc275_1 0.486339737469
Lrlc275 nrlc275_1 nrlc275_2 9.2517151714e-09
Crlc275 nrlc275_2 rlc13 4.34610517936e-11
* RLC[277] rlc9-rlc15
Rrlc277 rlc9 nrlc277_1 14.4766296916
Lrlc277 nrlc277_1 nrlc277_2 6.46558841683e-07
Crlc277 nrlc277_2 rlc15 3.42791950199e-12
* RLC[278] rlc9-P1B
Rrlc278 rlc9 nrlc278_1 529.175276044
Lrlc278 nrlc278_1 nrlc278_2 3.02625528438e-05
Crlc278 nrlc278_2 P1B 1.32923616612e-13
* RLC[280] rlc10-rlc12
Rrlc280 rlc10 nrlc280_1 4.65157691852
Lrlc280 nrlc280_1 nrlc280_2 2.79563126869e-07
Crlc280 nrlc280_2 rlc12 1.5178771801e-11
* RLC[281] rlc10-rlc13
Rrlc281 rlc10 nrlc281_1 28.6023019228
Lrlc281 nrlc281_1 nrlc281_2 9.62618054838e-07
Crlc281 nrlc281_2 rlc13 1.3074031295e-12
* RLC[283] rlc10-rlc15
Rrlc283 rlc10 nrlc283_1 14264.2013534
Lrlc283 nrlc283_1 nrlc283_2 0.0403201027953
Crlc283 nrlc283_2 rlc15 3.31601282214e-07
* RLC[285] rlc11-rlc12
Rrlc285 rlc11 nrlc285_1 11.2705312496
Lrlc285 nrlc285_1 nrlc285_2 2.50013817264e-07
Crlc285 nrlc285_2 rlc12 1.12655875161e-11
* RLC[286] rlc11-rlc13
Rrlc286 rlc11 nrlc286_1 573.923069216
Lrlc286 nrlc286_1 nrlc286_2 4.20355923975e-06
Crlc286 nrlc286_2 rlc13 8.52771849624e-12
* RLC[287] rlc11-rlc14
Rrlc287 rlc11 nrlc287_1 42.275250336
Lrlc287 nrlc287_1 nrlc287_2 2.25730919009e-06
Crlc287 nrlc287_2 rlc14 1.40424767541e-12
* RLC[290] rlc12-rlc13
Rrlc290 rlc12 nrlc290_1 100.56521836
Lrlc290 nrlc290_1 nrlc290_2 2.32832541212e-06
Crlc290 nrlc290_2 rlc13 2.55802960789e-13
* RLC[291] rlc12-rlc14
Rrlc291 rlc12 nrlc291_1 324.56598714
Lrlc291 nrlc291_1 nrlc291_2 2.95769678642e-06
Crlc291 nrlc291_2 rlc14 3.67921007415e-12
* RLC[292] rlc12-rlc15
Rrlc292 rlc12 nrlc292_1 19.7432826042
Lrlc292 nrlc292_1 nrlc292_2 8.64684775676e-07
Crlc292 nrlc292_2 rlc15 2.46477101984e-12
* RLC[294] rlc13-rlc14
Rrlc294 rlc13 nrlc294_1 9.22863249424
Lrlc294 nrlc294_1 nrlc294_2 3.87585966272e-07
Crlc294 nrlc294_2 rlc14 5.0565095389e-12
* RLC[295] rlc13-rlc15
Rrlc295 rlc13 nrlc295_1 15.0237152361
Lrlc295 nrlc295_1 nrlc295_2 5.30283528913e-07
Crlc295 nrlc295_2 rlc15 2.61042332763e-12
* RLC[296] rlc13-P1B
Rrlc296 rlc13 nrlc296_1 563.693612848
Lrlc296 nrlc296_1 nrlc296_2 2.43490934531e-06
Crlc296 nrlc296_2 P1B 8.51444360566e-15
* RLC[299] rlc15-P1B
Rrlc299 rlc15 nrlc299_1 617.742059711
Lrlc299 nrlc299_1 nrlc299_2 2.46184323458e-06
Crlc299 nrlc299_2 P1B 7.16809151605e-15
* DC[0] P1A-P2A
Rdc0 P1A ndc0_1 0.0117981930084
Ldc0 ndc0_1 P2A 4.12650900765e-08
* DC[16] P2A-P3B
Rdc16 P2A ndc16_1 2570499.18991
Ldc16 ndc16_1 P3B 0.409107652288
* DC[23] P3A-P4A
Rdc23 P3A ndc23_1 0.0201694403958
Ldc23 ndc23_1 P4A 7.66878158375e-08
* DC[24] P3A-P1B
Rdc24 P3A ndc24_1 328271.322458
Ldc24 ndc24_1 P1B 0.679877360583
* DC[38] P4A-dc1
Rdc38 P4A ndc38_1 521807.471067
Ldc38 ndc38_1 dc1 0.332993045948
* DC[42] P1B-P2B
Rdc42 P1B ndc42_1 1.37873368066
Ldc42 ndc42_1 P2B 0.000101873394221
* DC[51] P2B-P4B
Rdc51 P2B ndc51_1 11.6744751875
Ldc51 ndc51_1 P4B 3.13752501224e-06
* DC[53] P2B-dc1
Rdc53 P2B ndc53_1 0.167143996552
Ldc53 ndc53_1 dc1 3.60615939102e-08
* DC[57] P3B-P4B
Rdc57 P3B ndc57_1 0.209304219481
Ldc57 ndc57_1 P4B 5.45492161548e-08
* DC[58] P3B-dc0
Rdc58 P3B ndc58_1 25.5041442041
Ldc58 ndc58_1 dc0 4.05911061941e-06
* DC[59] P3B-dc1
Rdc59 P3B ndc59_1 15.0548056915
Ldc59 ndc59_1 dc1 3.34433327783e-05
* DC[62] P3B-P1B
Rdc62 P3B ndc62_1 4.17031579247
Ldc62 ndc62_1 P1B 7.78167505865e-07
* DC[63] P4B-dc0
Rdc63 P4B ndc63_1 126.357534189
Ldc63 ndc63_1 dc0 0.000300721146537
* DC[64] P4B-dc1
Rdc64 P4B ndc64_1 220.494560196
Ldc64 ndc64_1 dc1 0.000434132923614
* DC[65] P4B-dc2
Rdc65 P4B ndc65_1 117.113980081
Ldc65 ndc65_1 dc2 0.00023090627462
* DC[68] dc0-dc1
Rdc68 dc0 ndc68_1 16.2596346597
Ldc68 ndc68_1 dc1 2.58780122897e-06
* DC[69] dc0-dc2
Rdc69 dc0 ndc69_1 34.6298141678
Ldc69 ndc69_1 dc2 5.51150610316e-06
* DC[72] dc1-dc2
Rdc72 dc1 ndc72_1 0.0211755655722
Ldc72 ndc72_1 dc2 3.37019593357e-09
* DC[74] dc1-P1B
Rdc74 dc1 ndc74_1 1.23632516624
Ldc74 ndc74_1 P1B 0.00017760154491
* ---- leaks
Rleak_P1A P1A P1B 1e+12
Rleak_P2A P2A P1B 1e+12
Rleak_P2B P2B P1B 1e+12
Rleak_P3A P3A P1B 1e+12
Rleak_P3B P3B P1B 1e+12
Rleak_P4A P4A P1B 1e+12
Rleak_P4B P4B P1B 1e+12
Rleak_dc0 dc0 P1B 1e+12
Rleak_dc1 dc1 P1B 1e+12
Rleak_dc2 dc2 P1B 1e+12
Rleak_rlc0 rlc0 P1B 1e+12
Rleak_rlc1 rlc1 P1B 1e+12
Rleak_rlc10 rlc10 P1B 1e+12
Rleak_rlc11 rlc11 P1B 1e+12
Rleak_rlc12 rlc12 P1B 1e+12
Rleak_rlc13 rlc13 P1B 1e+12
Rleak_rlc14 rlc14 P1B 1e+12
Rleak_rlc15 rlc15 P1B 1e+12
Rleak_rlc2 rlc2 P1B 1e+12
Rleak_rlc3 rlc3 P1B 1e+12
Rleak_rlc4 rlc4 P1B 1e+12
Rleak_rlc5 rlc5 P1B 1e+12
Rleak_rlc6 rlc6 P1B 1e+12
Rleak_rlc7 rlc7 P1B 1e+12
Rleak_rlc8 rlc8 P1B 1e+12
Rleak_rlc9 rlc9 P1B 1e+12
.ends fitted
