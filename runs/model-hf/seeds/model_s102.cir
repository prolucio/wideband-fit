* fitted: 4-port fitted model, reference z0 = 50 Ohm
* port p is PpA (+) to PpB (-); the reference node is P1B
.subckt fitted P1A P1B P2A P2B P3A P3B P4A P4B
* ---- branches
* RLC[0] P1A-P2A
Rrlc0 P1A nrlc0_1 3.82237467497
Lrlc0 nrlc0_1 nrlc0_2 1.90762890654e-08
Crlc0 nrlc0_2 P2A 1.45072426532e-12
* RLC[2] P1A-P4A
Rrlc2 P1A nrlc2_1 1486.95549813
Lrlc2 nrlc2_1 nrlc2_2 3.99598478059e-07
Crlc2 nrlc2_2 P4A 7.82328926432e-15
* RLC[4] P1A-P2B
Rrlc4 P1A nrlc4_1 251195.334545
Lrlc4 nrlc4_1 nrlc4_2 1.38237143518e-09
Crlc4 nrlc4_2 P2B 5.99017982977e-14
* RLC[7] P1A-rlc0
Rrlc7 P1A nrlc7_1 2477.87120469
Lrlc7 nrlc7_1 nrlc7_2 2.23391636687e-05
Crlc7 nrlc7_2 rlc0 4.04265744607e-15
* RLC[9] P1A-rlc2
Rrlc9 P1A nrlc9_1 3132046.22664
Lrlc9 nrlc9_1 nrlc9_2 0.210607098112
Crlc9 nrlc9_2 rlc2 0.000809458716122
* RLC[15] P1A-rlc8
Rrlc15 P1A nrlc15_1 945263.96189
Lrlc15 nrlc15_1 nrlc15_2 0.595991556966
Crlc15 nrlc15_2 rlc8 3.02861110509e-12
* RLC[18] P1A-rlc11
Rrlc18 P1A nrlc18_1 3515561.05481
Lrlc18 nrlc18_1 nrlc18_2 0.00105230906615
Crlc18 nrlc18_2 rlc11 3.48022247472e-13
* RLC[19] P1A-rlc12
Rrlc19 P1A nrlc19_1 81.7164112333
Lrlc19 nrlc19_1 nrlc19_2 1.5266523605e-07
Crlc19 nrlc19_2 rlc12 2.54026528638e-14
* RLC[20] P1A-rlc13
Rrlc20 P1A nrlc20_1 2439.73654403
Lrlc20 nrlc20_1 nrlc20_2 1.15011839722e-07
Crlc20 nrlc20_2 rlc13 8.81510851183e-15
* RLC[21] P1A-rlc14
Rrlc21 P1A nrlc21_1 2.34490554595
Lrlc21 nrlc21_1 nrlc21_2 2.61480468274e-08
Crlc21 nrlc21_2 rlc14 5.28379594249e-12
* RLC[22] P1A-rlc15
Rrlc22 P1A nrlc22_1 371.028101525
Lrlc22 nrlc22_1 nrlc22_2 2.27533508388e-08
Crlc22 nrlc22_2 rlc15 1.10789158967e-13
* RLC[25] P2A-P4A
Rrlc25 P2A nrlc25_1 1723.75568295
Lrlc25 nrlc25_1 nrlc25_2 1.50469740926e-05
Crlc25 nrlc25_2 P4A 5.62671919308e-15
* RLC[28] P2A-P3B
Rrlc28 P2A nrlc28_1 12873.4832619
Lrlc28 nrlc28_1 nrlc28_2 0.000142342478914
Crlc28 nrlc28_2 P3B 9.54332842763e-16
* RLC[29] P2A-P4B
Rrlc29 P2A nrlc29_1 31080.021281
Lrlc29 nrlc29_1 nrlc29_2 6.20040531485e-06
Crlc29 nrlc29_2 P4B 1.26499988723e-14
* RLC[30] P2A-rlc0
Rrlc30 P2A nrlc30_1 0.0137316366906
Lrlc30 nrlc30_1 nrlc30_2 5.01129308574e-13
Crlc30 nrlc30_2 rlc0 2.95299481871e-12
* RLC[31] P2A-rlc1
Rrlc31 P2A nrlc31_1 26.2088306872
Lrlc31 nrlc31_1 nrlc31_2 2.25465998915e-07
Crlc31 nrlc31_2 rlc1 3.64706293798e-13
* RLC[32] P2A-rlc2
Rrlc32 P2A nrlc32_1 15747.1747266
Lrlc32 nrlc32_1 nrlc32_2 0.000392512617007
Crlc32 nrlc32_2 rlc2 5.37791223815e-15
* RLC[33] P2A-rlc3
Rrlc33 P2A nrlc33_1 79.8772075314
Lrlc33 nrlc33_1 nrlc33_2 1.46188663495e-07
Crlc33 nrlc33_2 rlc3 2.54580677984e-14
* RLC[36] P2A-rlc6
Rrlc36 P2A nrlc36_1 1854.28516526
Lrlc36 nrlc36_1 nrlc36_2 3.3808019269e-06
Crlc36 nrlc36_2 rlc6 1.09250685353e-15
* RLC[37] P2A-rlc7
Rrlc37 P2A nrlc37_1 2.50888236595
Lrlc37 nrlc37_1 nrlc37_2 2.15830698771e-08
Crlc37 nrlc37_2 rlc7 3.8098695821e-12
* RLC[38] P2A-rlc8
Rrlc38 P2A nrlc38_1 0.0322105314704
Lrlc38 nrlc38_1 nrlc38_2 3.1858800534e-14
Crlc38 nrlc38_2 rlc8 3.41185943196e-14
* RLC[39] P2A-rlc9
Rrlc39 P2A nrlc39_1 29125.1779682
Lrlc39 nrlc39_1 nrlc39_2 0.000164982987276
Crlc39 nrlc39_2 rlc9 8.27361146921e-15
* RLC[40] P2A-rlc10
Rrlc40 P2A nrlc40_1 11219.3134719
Lrlc40 nrlc40_1 nrlc40_2 4.37983211314e-06
Crlc40 nrlc40_2 rlc10 3.21623088101e-13
* RLC[41] P2A-rlc11
Rrlc41 P2A nrlc41_1 292.109822088
Lrlc41 nrlc41_1 nrlc41_2 2.46409210678e-06
Crlc41 nrlc41_2 rlc11 3.20864823352e-14
* RLC[45] P2A-rlc15
Rrlc45 P2A nrlc45_1 177308.957703
Lrlc45 nrlc45_1 nrlc45_2 0.00062880633064
Crlc45 nrlc45_2 rlc15 4.51168310405e-12
* RLC[47] P3A-P4A
Rrlc47 P3A nrlc47_1 8500.29158796
Lrlc47 nrlc47_1 nrlc47_2 3.79481545008e-05
Crlc47 nrlc47_2 P4A 1.81399464202e-14
* RLC[48] P3A-P1B
Rrlc48 P3A nrlc48_1 28.2420515458
Lrlc48 nrlc48_1 nrlc48_2 8.8481555677e-08
Crlc48 nrlc48_2 P1B 1.23258749581e-13
* RLC[51] P3A-P4B
Rrlc51 P3A nrlc51_1 2.10149558275
Lrlc51 nrlc51_1 nrlc51_2 3.15070648363e-08
Crlc51 nrlc51_2 P4B 7.92699299246e-12
* RLC[57] P3A-rlc5
Rrlc57 P3A nrlc57_1 28.1871612026
Lrlc57 nrlc57_1 nrlc57_2 8.92616771883e-08
Crlc57 nrlc57_2 rlc5 1.24830254202e-13
* RLC[58] P3A-rlc6
Rrlc58 P3A nrlc58_1 26.8300493591
Lrlc58 nrlc58_1 nrlc58_2 1.43645696331e-07
Crlc58 nrlc58_2 rlc6 2.21721172324e-13
* RLC[59] P3A-rlc7
Rrlc59 P3A nrlc59_1 9.80006767633
Lrlc59 nrlc59_1 nrlc59_2 2.9784325405e-08
Crlc59 nrlc59_2 rlc7 3.44577653329e-13
* RLC[60] P3A-rlc8
Rrlc60 P3A nrlc60_1 9.54306582288
Lrlc60 nrlc60_1 nrlc60_2 4.58873558523e-08
Crlc60 nrlc60_2 rlc8 5.59853870589e-13
* RLC[62] P3A-rlc10
Rrlc62 P3A nrlc62_1 47.6816993205
Lrlc62 nrlc62_1 nrlc62_2 1.58587422068e-07
Crlc62 nrlc62_2 rlc10 7.75037614661e-14
* RLC[63] P3A-rlc11
Rrlc63 P3A nrlc63_1 4254.12861239
Lrlc63 nrlc63_1 nrlc63_2 4.17964675801e-05
Crlc63 nrlc63_2 rlc11 4.21449274851e-14
* RLC[64] P3A-rlc12
Rrlc64 P3A nrlc64_1 13.1246017053
Lrlc64 nrlc64_1 nrlc64_2 6.22150803767e-08
Crlc64 nrlc64_2 rlc12 4.01310840866e-13
* RLC[68] P3A-P1B
Rrlc68 P3A nrlc68_1 300970.824075
Lrlc68 nrlc68_1 nrlc68_2 0.00318073421256
Crlc68 nrlc68_2 P1B 1.13216165242e-11
* RLC[71] P4A-P3B
Rrlc71 P4A nrlc71_1 1557.77282279
Lrlc71 nrlc71_1 nrlc71_2 5.60042290796e-05
Crlc71 nrlc71_2 P3B 2.56430729805e-14
* RLC[72] P4A-P4B
Rrlc72 P4A nrlc72_1 3.26052905977
Lrlc72 nrlc72_1 nrlc72_2 5.80758482265e-09
Crlc72 nrlc72_2 P4B 1.26367169887e-12
* RLC[73] P4A-rlc0
Rrlc73 P4A nrlc73_1 292.723090163
Lrlc73 nrlc73_1 nrlc73_2 4.28687690316e-06
Crlc73 nrlc73_2 rlc0 5.55884470111e-14
* RLC[74] P4A-rlc1
Rrlc74 P4A nrlc74_1 295182.49742
Lrlc74 nrlc74_1 nrlc74_2 1
Crlc74 nrlc74_2 rlc1 2.47065586143e-10
* RLC[76] P4A-rlc3
Rrlc76 P4A nrlc76_1 1.48099063631
Lrlc76 nrlc76_1 nrlc76_2 1.7951438042e-08
Crlc76 nrlc76_2 rlc3 9.0939405282e-12
* RLC[78] P4A-rlc5
Rrlc78 P4A nrlc78_1 182395.770917
Lrlc78 nrlc78_1 nrlc78_2 0.00196858675192
Crlc78 nrlc78_2 rlc5 4.1326064731e-06
* RLC[79] P4A-rlc6
Rrlc79 P4A nrlc79_1 830.058368808
Lrlc79 nrlc79_1 nrlc79_2 1.37669732267e-05
Crlc79 nrlc79_2 rlc6 2.22013147165e-14
* RLC[83] P4A-rlc10
Rrlc83 P4A nrlc83_1 77.5102077716
Lrlc83 nrlc83_1 nrlc83_2 2.13697339438e-08
Crlc83 nrlc83_2 rlc10 3.95219899725e-15
* RLC[86] P4A-rlc13
Rrlc86 P4A nrlc86_1 1003418.19248
Lrlc86 nrlc86_1 nrlc86_2 0.0109100248333
Crlc86 nrlc86_2 rlc13 2.89896723037e-07
* RLC[91] P1B-P3B
Rrlc91 P1B nrlc91_1 10.1535055196
Lrlc91 nrlc91_1 nrlc91_2 2.03136980372e-08
Crlc91 nrlc91_2 P3B 1.06472223167e-08
* RLC[92] P1B-P4B
Rrlc92 P1B nrlc92_1 2852.76857341
Lrlc92 nrlc92_1 nrlc92_2 1.74932199679e-05
Crlc92 nrlc92_2 P4B 8.89178469488e-13
* RLC[93] P1B-rlc0
Rrlc93 P1B nrlc93_1 0.203894671937
Lrlc93 nrlc93_1 nrlc93_2 7.06345715527e-10
Crlc93 nrlc93_2 rlc0 4.43021342664e-07
* RLC[95] P1B-rlc2
Rrlc95 P1B nrlc95_1 769.17057421
Lrlc95 nrlc95_1 nrlc95_2 1.01930208344e-05
Crlc95 nrlc95_2 rlc2 1.93399584035e-13
* RLC[98] P1B-rlc5
Rrlc98 P1B nrlc98_1 0.01
Lrlc98 nrlc98_1 nrlc98_2 3.73961011467e-12
Crlc98 nrlc98_2 rlc5 4.49061050791e-10
* RLC[99] P1B-rlc6
Rrlc99 P1B nrlc99_1 8.82010254525
Lrlc99 nrlc99_1 nrlc99_2 1.35337076342e-07
Crlc99 nrlc99_2 rlc6 1.93297844888e-12
* RLC[100] P1B-rlc7
Rrlc100 P1B nrlc100_1 0.0194414990216
Lrlc100 nrlc100_1 nrlc100_2 4.92672811669e-11
Crlc100 nrlc100_2 rlc7 1.44829353204e-10
* RLC[101] P1B-rlc8
Rrlc101 P1B nrlc101_1 13.9646472423
Lrlc101 nrlc101_1 nrlc101_2 3.34515960724e-07
Crlc101 nrlc101_2 rlc8 1.96816786656e-12
* RLC[102] P1B-rlc9
Rrlc102 P1B nrlc102_1 0.135617319787
Lrlc102 nrlc102_1 nrlc102_2 4.38270150923e-07
Crlc102 nrlc102_2 rlc9 2.64770179365e-08
* RLC[103] P1B-rlc10
Rrlc103 P1B nrlc103_1 2.47180323261
Lrlc103 nrlc103_1 nrlc103_2 6.10877094361e-09
Crlc103 nrlc103_2 rlc10 1.11092192957e-12
* RLC[104] P1B-rlc11
Rrlc104 P1B nrlc104_1 0.0145641542002
Lrlc104 nrlc104_1 nrlc104_2 2.40550944697e-09
Crlc104 nrlc104_2 rlc11 1.53192782234e-07
* RLC[106] P1B-rlc13
Rrlc106 P1B nrlc106_1 3.37007261229
Lrlc106 nrlc106_1 nrlc106_2 9.90907659007e-09
Crlc106 nrlc106_2 rlc13 9.69420409973e-13
* RLC[110] P2B-P3B
Rrlc110 P2B nrlc110_1 27.3866209399
Lrlc110 nrlc110_1 nrlc110_2 8.58574108879e-08
Crlc110 nrlc110_2 P3B 1.27191584278e-13
* RLC[114] P2B-rlc2
Rrlc114 P2B nrlc114_1 1143.66485554
Lrlc114 nrlc114_1 nrlc114_2 7.92386783129e-06
Crlc114 nrlc114_2 rlc2 1.18097103578e-10
* RLC[119] P2B-rlc7
Rrlc119 P2B nrlc119_1 540.931777994
Lrlc119 nrlc119_1 nrlc119_2 1.66778100261e-06
Crlc119 nrlc119_2 rlc7 6.33302965917e-15
* RLC[121] P2B-rlc9
Rrlc121 P2B nrlc121_1 77.4889338602
Lrlc121 nrlc121_1 nrlc121_2 1.71739074447e-05
Crlc121 nrlc121_2 rlc9 7.32456394832e-09
* RLC[122] P2B-rlc10
Rrlc122 P2B nrlc122_1 30.2298402569
Lrlc122 nrlc122_1 nrlc122_2 9.58533202547e-08
Crlc122 nrlc122_2 rlc10 1.16544812372e-13
* RLC[123] P2B-rlc11
Rrlc123 P2B nrlc123_1 4.2200231793
Lrlc123 nrlc123_1 nrlc123_2 2.33304926396e-06
Crlc123 nrlc123_2 rlc11 1.06818305806e-05
* RLC[125] P2B-rlc13
Rrlc125 P2B nrlc125_1 9.9681525134
Lrlc125 nrlc125_1 nrlc125_2 1.30948149785e-06
Crlc125 nrlc125_2 rlc13 9.3160409611e-05
* RLC[127] P2B-rlc15
Rrlc127 P2B nrlc127_1 0.01
Lrlc127 nrlc127_1 nrlc127_2 1.08690992275e-09
Crlc127 nrlc127_2 rlc15 1.0955957012e-05
* RLC[128] P2B-P1B
Rrlc128 P2B nrlc128_1 1962.15147202
Lrlc128 nrlc128_1 nrlc128_2 2.1579867131e-05
Crlc128 nrlc128_2 P1B 6.89340679904e-15
* RLC[130] P3B-rlc0
Rrlc130 P3B nrlc130_1 1.69176436908
Lrlc130 nrlc130_1 nrlc130_2 6.99852070445e-08
Crlc130 nrlc130_2 rlc0 2.27277112342e-07
* RLC[131] P3B-rlc1
Rrlc131 P3B nrlc131_1 242.591802781
Lrlc131 nrlc131_1 nrlc131_2 1.96833255724e-06
Crlc131 nrlc131_2 rlc1 3.71623973638e-14
* RLC[132] P3B-rlc2
Rrlc132 P3B nrlc132_1 8.09930445289
Lrlc132 nrlc132_1 nrlc132_2 1.54702975213e-07
Crlc132 nrlc132_2 rlc2 2.62035847058e-12
* RLC[133] P3B-rlc3
Rrlc133 P3B nrlc133_1 2.80534402805
Lrlc133 nrlc133_1 nrlc133_2 9.07584538743e-08
Crlc133 nrlc133_2 rlc3 1.2813634264e-11
* RLC[135] P3B-rlc5
Rrlc135 P3B nrlc135_1 0.01
Lrlc135 nrlc135_1 nrlc135_2 1.9778926279e-13
Crlc135 nrlc135_2 rlc5 4.36357004531e-10
* RLC[136] P3B-rlc6
Rrlc136 P3B nrlc136_1 97.8016665425
Lrlc136 nrlc136_1 nrlc136_2 1.27717612413e-08
Crlc136 nrlc136_2 rlc6 1.91298524149e-13
* RLC[137] P3B-rlc7
Rrlc137 P3B nrlc137_1 61.2076791759
Lrlc137 nrlc137_1 nrlc137_2 9.07012998797e-07
Crlc137 nrlc137_2 rlc7 2.69004271736e-13
* RLC[138] P3B-rlc8
Rrlc138 P3B nrlc138_1 1.57512195307
Lrlc138 nrlc138_1 nrlc138_2 2.73258985047e-08
Crlc138 nrlc138_2 rlc8 1.22378062335e-11
* RLC[140] P3B-rlc10
Rrlc140 P3B nrlc140_1 24.1001524232
Lrlc140 nrlc140_1 nrlc140_2 3.85338058894e-07
Crlc140 nrlc140_2 rlc10 7.37156700148e-13
* RLC[141] P3B-rlc11
Rrlc141 P3B nrlc141_1 6.93941503876
Lrlc141 nrlc141_1 nrlc141_2 4.0082713999e-08
Crlc141 nrlc141_2 rlc11 3.79694582481e-12
* RLC[144] P3B-rlc14
Rrlc144 P3B nrlc144_1 3473.90029341
Lrlc144 nrlc144_1 nrlc144_2 1.63765933116e-05
Crlc144 nrlc144_2 rlc14 1.771456876e-14
* RLC[147] P4B-rlc0
Rrlc147 P4B nrlc147_1 2243.49225155
Lrlc147 nrlc147_1 nrlc147_2 1.43854100192e-05
Crlc147 nrlc147_2 rlc0 2.84333790518e-12
* RLC[148] P4B-rlc1
Rrlc148 P4B nrlc148_1 12935.8479023
Lrlc148 nrlc148_1 nrlc148_2 2.64613484196e-05
Crlc148 nrlc148_2 rlc1 0.000105217717077
* RLC[150] P4B-rlc3
Rrlc150 P4B nrlc150_1 35.2751560647
Lrlc150 nrlc150_1 nrlc150_2 0.0542645407441
Crlc150 nrlc150_2 rlc3 3.6604096272e-07
* RLC[152] P4B-rlc5
Rrlc152 P4B nrlc152_1 12.2369929899
Lrlc152 nrlc152_1 nrlc152_2 6.75717080922e-08
Crlc152 nrlc152_2 rlc5 5.01386879906e-13
* RLC[153] P4B-rlc6
Rrlc153 P4B nrlc153_1 0.387749657095
Lrlc153 nrlc153_1 nrlc153_2 3.13342567711e-10
Crlc153 nrlc153_2 rlc6 2.31565600017e-12
* RLC[154] P4B-rlc7
Rrlc154 P4B nrlc154_1 5357.25837366
Lrlc154 nrlc154_1 nrlc154_2 5.56566737486e-05
Crlc154 nrlc154_2 rlc7 1.32459149813e-14
* RLC[156] P4B-rlc9
Rrlc156 P4B nrlc156_1 36.5869342233
Lrlc156 nrlc156_1 nrlc156_2 2.19771544153e-07
Crlc156 nrlc156_2 rlc9 1.82421873198e-13
* RLC[158] P4B-rlc11
Rrlc158 P4B nrlc158_1 4.07947525284
Lrlc158 nrlc158_1 nrlc158_2 2.20899938974e-08
Crlc158 nrlc158_2 rlc11 1.47483854906e-12
* RLC[159] P4B-rlc12
Rrlc159 P4B nrlc159_1 192.546711354
Lrlc159 nrlc159_1 nrlc159_2 4.0300186955e-07
Crlc159 nrlc159_2 rlc12 1.20779253391e-14
* RLC[160] P4B-rlc13
Rrlc160 P4B nrlc160_1 978.165372706
Lrlc160 nrlc160_1 nrlc160_2 7.15162740312e-06
Crlc160 nrlc160_2 rlc13 4.32210662802e-11
* RLC[161] P4B-rlc14
Rrlc161 P4B nrlc161_1 178.240768511
Lrlc161 nrlc161_1 nrlc161_2 6.62386927234e-07
Crlc161 nrlc161_2 rlc14 2.31662186594e-14
* RLC[164] rlc0-rlc1
Rrlc164 rlc0 nrlc164_1 0.396865375416
Lrlc164 nrlc164_1 nrlc164_2 1.19355772909e-09
Crlc164 nrlc164_2 rlc1 8.42004667811e-12
* RLC[165] rlc0-rlc2
Rrlc165 rlc0 nrlc165_1 2.5084113892
Lrlc165 nrlc165_1 nrlc165_2 7.39362682278e-08
Crlc165 nrlc165_2 rlc2 1.30562208988e-11
* RLC[166] rlc0-rlc3
Rrlc166 rlc0 nrlc166_1 2066.73465782
Lrlc166 nrlc166_1 nrlc166_2 0.000137324332746
Crlc166 nrlc166_2 rlc3 2.50409411073e-12
* RLC[167] rlc0-rlc4
Rrlc167 rlc0 nrlc167_1 0.344838439668
Lrlc167 nrlc167_1 nrlc167_2 1.96083858161e-09
Crlc167 nrlc167_2 rlc4 1.8321793814e-11
* RLC[168] rlc0-rlc5
Rrlc168 rlc0 nrlc168_1 4.15753708293
Lrlc168 nrlc168_1 nrlc168_2 1.32563951618e-07
Crlc168 nrlc168_2 rlc5 8.52139444941e-12
* RLC[170] rlc0-rlc7
Rrlc170 rlc0 nrlc170_1 192541.943987
Lrlc170 nrlc170_1 nrlc170_2 3.69573977527e-08
Crlc170 nrlc170_2 rlc7 3.29576898308e-12
* RLC[171] rlc0-rlc8
Rrlc171 rlc0 nrlc171_1 69.4778456176
Lrlc171 nrlc171_1 nrlc171_2 1.09201004314e-06
Crlc171 nrlc171_2 rlc8 4.61631839038e-13
* RLC[174] rlc0-rlc11
Rrlc174 rlc0 nrlc174_1 9.24277003859
Lrlc174 nrlc174_1 nrlc174_2 9.66390119859e-08
Crlc174 nrlc174_2 rlc11 6.24986786479e-11
* RLC[175] rlc0-rlc12
Rrlc175 rlc0 nrlc175_1 910.323562918
Lrlc175 nrlc175_1 nrlc175_2 4.48712799681e-06
Crlc175 nrlc175_2 rlc12 3.8446207668e-11
* RLC[176] rlc0-rlc13
Rrlc176 rlc0 nrlc176_1 75.4038305872
Lrlc176 nrlc176_1 nrlc176_2 1.25973250791e-06
Crlc176 nrlc176_2 rlc13 2.46178631275e-13
* RLC[177] rlc0-rlc14
Rrlc177 rlc0 nrlc177_1 2471.2065899
Lrlc177 nrlc177_1 nrlc177_2 2.58302805372e-05
Crlc177 nrlc177_2 rlc14 4.69968236734e-15
* RLC[179] rlc0-P1B
Rrlc179 rlc0 nrlc179_1 9.09559780343
Lrlc179 nrlc179_1 nrlc179_2 9.35678832598e-08
Crlc179 nrlc179_2 P1B 2.29622174412e-12
* RLC[180] rlc1-rlc2
Rrlc180 rlc1 nrlc180_1 30.2668469112
Lrlc180 nrlc180_1 nrlc180_2 1.27722676808e-09
Crlc180 nrlc180_2 rlc2 7.08876523582e-13
* RLC[183] rlc1-rlc5
Rrlc183 rlc1 nrlc183_1 49.866059054
Lrlc183 nrlc183_1 nrlc183_2 7.62444916974e-07
Crlc183 nrlc183_2 rlc5 3.40687241605e-13
* RLC[184] rlc1-rlc6
Rrlc184 rlc1 nrlc184_1 9.46510382537
Lrlc184 nrlc184_1 nrlc184_2 2.21923213085e-07
Crlc184 nrlc184_2 rlc6 6.621889099e-12
* RLC[185] rlc1-rlc7
Rrlc185 rlc1 nrlc185_1 2.27029302171
Lrlc185 nrlc185_1 nrlc185_2 1.99201186499e-08
Crlc185 nrlc185_2 rlc7 4.2942327816e-12
* RLC[190] rlc1-rlc12
Rrlc190 rlc1 nrlc190_1 25095.0860149
Lrlc190 nrlc190_1 nrlc190_2 0.00849806262489
Crlc190 nrlc190_2 rlc12 8.2827262534e-11
* RLC[191] rlc1-rlc13
Rrlc191 rlc1 nrlc191_1 229.695613685
Lrlc191 nrlc191_1 nrlc191_2 3.48752674437e-06
Crlc191 nrlc191_2 rlc13 7.34462511648e-14
* RLC[192] rlc1-rlc14
Rrlc192 rlc1 nrlc192_1 1805.60313341
Lrlc192 nrlc192_1 nrlc192_2 1.06952714966e-05
Crlc192 nrlc192_2 rlc14 8.56427380478e-13
* RLC[193] rlc1-rlc15
Rrlc193 rlc1 nrlc193_1 2715.36113372
Lrlc193 nrlc193_1 nrlc193_2 1.58181456986e-05
Crlc193 nrlc193_2 rlc15 2.54527540826e-11
* RLC[194] rlc1-P1B
Rrlc194 rlc1 nrlc194_1 64.4450953775
Lrlc194 nrlc194_1 nrlc194_2 8.06195219996e-07
Crlc194 nrlc194_2 P1B 2.15684019201e-13
* RLC[195] rlc2-rlc3
Rrlc195 rlc2 nrlc195_1 0.01
Lrlc195 nrlc195_1 nrlc195_2 4.62628853468e-09
Crlc195 nrlc195_2 rlc3 0.000990107840753
* RLC[197] rlc2-rlc5
Rrlc197 rlc2 nrlc197_1 0.527246904067
Lrlc197 nrlc197_1 nrlc197_2 1.37724012595e-08
Crlc197 nrlc197_2 rlc5 5.50476877509e-11
* RLC[198] rlc2-rlc6
Rrlc198 rlc2 nrlc198_1 0.593527326696
Lrlc198 nrlc198_1 nrlc198_2 1.83318475596e-08
Crlc198 nrlc198_2 rlc6 5.78205594422e-11
* RLC[199] rlc2-rlc7
Rrlc199 rlc2 nrlc199_1 327.434705402
Lrlc199 nrlc199_1 nrlc199_2 1.55932729216e-06
Crlc199 nrlc199_2 rlc7 0.000748087256611
* RLC[201] rlc2-rlc9
Rrlc201 rlc2 nrlc201_1 4.31017329489
Lrlc201 nrlc201_1 nrlc201_2 1.23959034996e-08
Crlc201 nrlc201_2 rlc9 7.41389129036e-13
* RLC[202] rlc2-rlc10
Rrlc202 rlc2 nrlc202_1 300.108403719
Lrlc202 nrlc202_1 nrlc202_2 1.94647123134e-06
Crlc202 nrlc202_2 rlc10 2.40131517938e-14
* RLC[203] rlc2-rlc11
Rrlc203 rlc2 nrlc203_1 2526.23821352
Lrlc203 nrlc203_1 nrlc203_2 1.60605485695e-05
Crlc203 nrlc203_2 rlc11 2.79620665574e-15
* RLC[204] rlc2-rlc12
Rrlc204 rlc2 nrlc204_1 815.059780001
Lrlc204 nrlc204_1 nrlc204_2 3.30474540203e-05
Crlc204 nrlc204_2 rlc12 1.19057701203e-10
* RLC[205] rlc2-rlc13
Rrlc205 rlc2 nrlc205_1 552.535486178
Lrlc205 nrlc205_1 nrlc205_2 4.14859787304e-05
Crlc205 nrlc205_2 rlc13 1.50986625862e-13
* RLC[209] rlc3-rlc4
Rrlc209 rlc3 nrlc209_1 3.50126162032
Lrlc209 nrlc209_1 nrlc209_2 2.36881227899e-07
Crlc209 nrlc209_2 rlc4 2.14703443428e-11
* RLC[210] rlc3-rlc5
Rrlc210 rlc3 nrlc210_1 21.8344850256
Lrlc210 nrlc210_1 nrlc210_2 6.17254692147e-07
Crlc210 nrlc210_2 rlc5 2.45580580949e-12
* RLC[212] rlc3-rlc7
Rrlc212 rlc3 nrlc212_1 0.01
Lrlc212 nrlc212_1 nrlc212_2 2.23673125081e-13
Crlc212 nrlc212_2 rlc7 4.52317561089e-12
* RLC[213] rlc3-rlc8
Rrlc213 rlc3 nrlc213_1 0.269928279763
Lrlc213 nrlc213_1 nrlc213_2 2.93765585594e-08
Crlc213 nrlc213_2 rlc8 4.47983103191e-10
* RLC[214] rlc3-rlc9
Rrlc214 rlc3 nrlc214_1 152.186650685
Lrlc214 nrlc214_1 nrlc214_2 2.75161067846e-06
Crlc214 nrlc214_2 rlc9 1.32005296926e-13
* RLC[215] rlc3-rlc10
Rrlc215 rlc3 nrlc215_1 16671.870685
Lrlc215 nrlc215_1 nrlc215_2 0.00180752558147
Crlc215 nrlc215_2 rlc10 1.02478825792e-11
* RLC[217] rlc3-rlc12
Rrlc217 rlc3 nrlc217_1 1.45685285666
Lrlc217 nrlc217_1 nrlc217_2 0.0020899179645
Crlc217 nrlc217_2 rlc12 1.09409579751e-06
* RLC[218] rlc3-rlc13
Rrlc218 rlc3 nrlc218_1 1842.59632555
Lrlc218 nrlc218_1 nrlc218_2 6.81645050301e-05
Crlc218 nrlc218_2 rlc13 2.17183505032e-11
* RLC[219] rlc3-rlc14
Rrlc219 rlc3 nrlc219_1 5668.27809452
Lrlc219 nrlc219_1 nrlc219_2 3.11057406247e-05
Crlc219 nrlc219_2 rlc14 4.80300898778e-13
* RLC[221] rlc3-P1B
Rrlc221 rlc3 nrlc221_1 0.0716622009505
Lrlc221 nrlc221_1 nrlc221_2 0.00462192394057
Crlc221 nrlc221_2 P1B 0.001
* RLC[222] rlc4-rlc5
Rrlc222 rlc4 nrlc222_1 13.9473174721
Lrlc222 nrlc222_1 nrlc222_2 5.10988728477e-07
Crlc222 nrlc222_2 rlc5 2.91868642351e-12
* RLC[223] rlc4-rlc6
Rrlc223 rlc4 nrlc223_1 153.208789835
Lrlc223 nrlc223_1 nrlc223_2 2.93563140043e-06
Crlc223 nrlc223_2 rlc6 1.3896059039e-13
* RLC[224] rlc4-rlc7
Rrlc224 rlc4 nrlc224_1 882.996267766
Lrlc224 nrlc224_1 nrlc224_2 7.92863246744e-06
Crlc224 nrlc224_2 rlc7 6.1848438786e-11
* RLC[226] rlc4-rlc9
Rrlc226 rlc4 nrlc226_1 0.0285110691319
Lrlc226 nrlc226_1 nrlc226_2 2.85475610104e-07
Crlc226 nrlc226_2 rlc9 3.90210987508e-07
* RLC[227] rlc4-rlc10
Rrlc227 rlc4 nrlc227_1 4.40143523875
Lrlc227 nrlc227_1 nrlc227_2 3.51587849523e-08
Crlc227 nrlc227_2 rlc10 2.016520847e-12
* RLC[229] rlc4-rlc12
Rrlc229 rlc4 nrlc229_1 19.9941918076
Lrlc229 nrlc229_1 nrlc229_2 2.26785184544e-08
Crlc229 nrlc229_2 rlc12 1.55277913209e-13
* RLC[230] rlc4-rlc13
Rrlc230 rlc4 nrlc230_1 28.2481843614
Lrlc230 nrlc230_1 nrlc230_2 7.47056739142e-07
Crlc230 nrlc230_2 rlc13 6.48310922116e-12
* RLC[233] rlc4-P1B
Rrlc233 rlc4 nrlc233_1 89.4041752158
Lrlc233 nrlc233_1 nrlc233_2 2.35817792285e-07
Crlc233 nrlc233_2 P1B 2.22005916119e-10
* RLC[234] rlc5-rlc6
Rrlc234 rlc5 nrlc234_1 2.0457163005
Lrlc234 nrlc234_1 nrlc234_2 0.00101180311232
Crlc234 nrlc234_2 rlc6 8.94453873531e-06
* RLC[235] rlc5-rlc7
Rrlc235 rlc5 nrlc235_1 270201.66336
Lrlc235 nrlc235_1 nrlc235_2 5.55232193559e-08
Crlc235 nrlc235_2 rlc7 7.50530173177e-13
* RLC[236] rlc5-rlc8
Rrlc236 rlc5 nrlc236_1 452.497057242
Lrlc236 nrlc236_1 nrlc236_2 3.8410457914e-05
Crlc236 nrlc236_2 rlc8 3.70522464122e-09
* RLC[237] rlc5-rlc9
Rrlc237 rlc5 nrlc237_1 160.35931476
Lrlc237 nrlc237_1 nrlc237_2 0.000110803532871
Crlc237 nrlc237_2 rlc9 4.78765353662e-12
* RLC[238] rlc5-rlc10
Rrlc238 rlc5 nrlc238_1 0.0153258392853
Lrlc238 nrlc238_1 nrlc238_2 8.09233972521e-12
Crlc238 nrlc238_2 rlc10 3.82809814029e-11
* RLC[239] rlc5-rlc11
Rrlc239 rlc5 nrlc239_1 2.68741576212
Lrlc239 nrlc239_1 nrlc239_2 3.23418497787e-08
Crlc239 nrlc239_2 rlc11 4.97568211005e-12
* RLC[240] rlc5-rlc12
Rrlc240 rlc5 nrlc240_1 246.097070633
Lrlc240 nrlc240_1 nrlc240_2 9.55377818103e-07
Crlc240 nrlc240_2 rlc12 2.94941029821e-11
* RLC[241] rlc5-rlc13
Rrlc241 rlc5 nrlc241_1 36.0548773758
Lrlc241 nrlc241_1 nrlc241_2 5.71064012715e-07
Crlc241 nrlc241_2 rlc13 4.88106102648e-13
* RLC[243] rlc5-rlc15
Rrlc243 rlc5 nrlc243_1 13.5026769732
Lrlc243 nrlc243_1 nrlc243_2 4.13707105534e-08
Crlc243 nrlc243_2 rlc15 2.52121983107e-13
* RLC[244] rlc5-P1B
Rrlc244 rlc5 nrlc244_1 6.56319542219
Lrlc244 nrlc244_1 nrlc244_2 9.86108159402e-08
Crlc244 nrlc244_2 P1B 2.54361496449e-12
* RLC[246] rlc6-rlc8
Rrlc246 rlc6 nrlc246_1 0.719373370671
Lrlc246 nrlc246_1 nrlc246_2 6.81742888129e-09
Crlc246 nrlc246_2 rlc8 1.46375837193e-11
* RLC[247] rlc6-rlc9
Rrlc247 rlc6 nrlc247_1 550.493121177
Lrlc247 nrlc247_1 nrlc247_2 3.52565322136e-06
Crlc247 nrlc247_2 rlc9 1.29268673109e-14
* RLC[248] rlc6-rlc10
Rrlc248 rlc6 nrlc248_1 12.0750973338
Lrlc248 nrlc248_1 nrlc248_2 2.96675710535e-05
Crlc248 nrlc248_2 rlc10 1.0996393259e-07
* RLC[249] rlc6-rlc11
Rrlc249 rlc6 nrlc249_1 121.550513026
Lrlc249 nrlc249_1 nrlc249_2 3.3446133493e-06
Crlc249 nrlc249_2 rlc11 2.51530015154e-13
* RLC[250] rlc6-rlc12
Rrlc250 rlc6 nrlc250_1 1.83818634361
Lrlc250 nrlc250_1 nrlc250_2 2.03212165218e-08
Crlc250 nrlc250_2 rlc12 6.68233314244e-12
* RLC[251] rlc6-rlc13
Rrlc251 rlc6 nrlc251_1 150.797974461
Lrlc251 nrlc251_1 nrlc251_2 3.86893454516e-07
Crlc251 nrlc251_2 rlc13 0.000228013783976
* RLC[252] rlc6-rlc14
Rrlc252 rlc6 nrlc252_1 124.056252658
Lrlc252 nrlc252_1 nrlc252_2 3.19753740748e-07
Crlc252 nrlc252_2 rlc14 2.30853412609e-14
* RLC[255] rlc7-rlc8
Rrlc255 rlc7 nrlc255_1 0.01
Lrlc255 nrlc255_1 nrlc255_2 5.57422913091e-14
Crlc255 nrlc255_2 rlc8 2.50845689322e-12
* RLC[256] rlc7-rlc9
Rrlc256 rlc7 nrlc256_1 6651.25036227
Lrlc256 nrlc256_1 nrlc256_2 0.00782211465645
Crlc256 nrlc256_2 rlc9 2.6004645107e-10
* RLC[257] rlc7-rlc10
Rrlc257 rlc7 nrlc257_1 2.88379037984
Lrlc257 nrlc257_1 nrlc257_2 9.61969833478e-09
Crlc257 nrlc257_2 rlc10 1.28526170078e-12
* RLC[258] rlc7-rlc11
Rrlc258 rlc7 nrlc258_1 7.57038478812
Lrlc258 nrlc258_1 nrlc258_2 2.30043799604e-08
Crlc258 nrlc258_2 rlc11 2.56039403259e-11
* RLC[259] rlc7-rlc12
Rrlc259 rlc7 nrlc259_1 188.604321462
Lrlc259 nrlc259_1 nrlc259_2 1.50022247733e-06
Crlc259 nrlc259_2 rlc12 1.32635619025e-09
* RLC[260] rlc7-rlc13
Rrlc260 rlc7 nrlc260_1 55.5900318354
Lrlc260 nrlc260_1 nrlc260_2 1.17356042041e-06
Crlc260 nrlc260_2 rlc13 4.21957877484e-13
* RLC[262] rlc7-rlc15
Rrlc262 rlc7 nrlc262_1 20.4858365763
Lrlc262 nrlc262_1 nrlc262_2 6.21947038493e-08
Crlc262 nrlc262_2 rlc15 1.64665829805e-13
* RLC[263] rlc7-P1B
Rrlc263 rlc7 nrlc263_1 1590.00934794
Lrlc263 nrlc263_1 nrlc263_2 2.80165336896e-06
Crlc263 nrlc263_2 P1B 7.39715246938e-10
* RLC[266] rlc8-rlc11
Rrlc266 rlc8 nrlc266_1 65.0406356781
Lrlc266 nrlc266_1 nrlc266_2 2.20277767051e-07
Crlc266 nrlc266_2 rlc11 5.07916018572e-06
* RLC[268] rlc8-rlc13
Rrlc268 rlc8 nrlc268_1 77.1421360864
Lrlc268 nrlc268_1 nrlc268_2 4.3222396653e-07
Crlc268 nrlc268_2 rlc13 1.45697740295e-11
* RLC[272] rlc9-rlc10
Rrlc272 rlc9 nrlc272_1 0.421982360151
Lrlc272 nrlc272_1 nrlc272_2 4.00741843698e-06
Crlc272 nrlc272_2 rlc10 1.15928985574e-07
* RLC[273] rlc9-rlc11
Rrlc273 rlc9 nrlc273_1 38.7085433545
Lrlc273 nrlc273_1 nrlc273_2 3.21065350107e-07
Crlc273 nrlc273_2 rlc11 2.38087871036e-13
* RLC[275] rlc9-rlc13
Rrlc275 rlc9 nrlc275_1 0.523605615865
Lrlc275 nrlc275_1 nrlc275_2 3.33873372568e-10
Crlc275 nrlc275_2 rlc13 1.35310245786e-12
* RLC[276] rlc9-rlc14
Rrlc276 rlc9 nrlc276_1 5559.31504024
Lrlc276 nrlc276_1 nrlc276_2 1.23788817912e-06
Crlc276 nrlc276_2 rlc14 8.00995142002e-15
* RLC[278] rlc9-P1B
Rrlc278 rlc9 nrlc278_1 4.18915931536
Lrlc278 nrlc278_1 nrlc278_2 2.39747933905e-06
Crlc278 nrlc278_2 P1B 1.51795399552e-10
* RLC[279] rlc10-rlc11
Rrlc279 rlc10 nrlc279_1 82.6151903792
Lrlc279 nrlc279_1 nrlc279_2 3.21638518082e-08
Crlc279 nrlc279_2 rlc11 3.31636053196e-08
* RLC[280] rlc10-rlc12
Rrlc280 rlc10 nrlc280_1 1738.00156081
Lrlc280 nrlc280_1 nrlc280_2 3.77222930287e-05
Crlc280 nrlc280_2 rlc12 1.38757111529e-14
* RLC[281] rlc10-rlc13
Rrlc281 rlc10 nrlc281_1 24.6771537883
Lrlc281 nrlc281_1 nrlc281_2 9.42121010113e-07
Crlc281 nrlc281_2 rlc13 1.71899274738e-12
* RLC[283] rlc10-rlc15
Rrlc283 rlc10 nrlc283_1 2.84139891502
Lrlc283 nrlc283_1 nrlc283_2 8.94449857123e-09
Crlc283 nrlc283_2 rlc15 1.23097453549e-12
* RLC[286] rlc11-rlc13
Rrlc286 rlc11 nrlc286_1 0.0116432319757
Lrlc286 nrlc286_1 nrlc286_2 9.03964306851e-09
Crlc286 nrlc286_2 rlc13 7.40903544809e-08
* RLC[287] rlc11-rlc14
Rrlc287 rlc11 nrlc287_1 8.6135272166
Lrlc287 nrlc287_1 nrlc287_2 4.0812673734e-08
Crlc287 nrlc287_2 rlc14 6.11210036828e-13
* RLC[289] rlc11-P1B
Rrlc289 rlc11 nrlc289_1 0.107814895059
Lrlc289 nrlc289_1 nrlc289_2 1.91869218924e-09
Crlc289 nrlc289_2 P1B 1.18954858508e-09
* RLC[290] rlc12-rlc13
Rrlc290 rlc12 nrlc290_1 1983.71579781
Lrlc290 nrlc290_1 nrlc290_2 1.9156311472e-05
Crlc290 nrlc290_2 rlc13 5.40891898361e-15
* RLC[292] rlc12-rlc15
Rrlc292 rlc12 nrlc292_1 7990.68550694
Lrlc292 nrlc292_1 nrlc292_2 0.000110311522664
Crlc292 nrlc292_2 rlc15 9.19774377183e-15
* RLC[293] rlc12-P1B
Rrlc293 rlc12 nrlc293_1 53.4571909257
Lrlc293 nrlc293_1 nrlc293_2 6.54225607916e-07
Crlc293 nrlc293_2 P1B 2.57136557414e-13
* RLC[297] rlc14-rlc15
Rrlc297 rlc14 nrlc297_1 0.01
Lrlc297 nrlc297_1 nrlc297_2 1.45150614835e-14
Crlc297 nrlc297_2 rlc15 4.83689505933e-08
* DC[0] P1A-P2A
Rdc0 P1A ndc0_1 0.0253694371133
Ldc0 ndc0_1 P2A 4.54363377575e-08
* DC[6] P1A-P4B
Rdc6 P1A ndc6_1 335692.34719
Ldc6 ndc6_1 P4B 0.637182032803
* DC[16] P2A-P3B
Rdc16 P2A ndc16_1 333760.704038
Ldc16 ndc16_1 P3B 0.23608049347
* DC[23] P3A-P4A
Rdc23 P3A ndc23_1 0.0803487827464
Ldc23 ndc23_1 P4A 7.21612368129e-08
* DC[42] P1B-P2B
Rdc42 P1B ndc42_1 0.601867814017
Ldc42 ndc42_1 P2B 2.35224865374e-07
* DC[43] P1B-P3B
Rdc43 P1B ndc43_1 8.01754416964
Ldc43 ndc43_1 P3B 1.48834821915e-06
* DC[45] P1B-dc0
Rdc45 P1B ndc45_1 0.735450036674
Ldc45 ndc45_1 dc0 3.04546319288e-07
* DC[46] P1B-dc1
Rdc46 P1B ndc46_1 1.3696835384
Ldc46 ndc46_1 dc1 4.10176038514e-07
* DC[47] P1B-dc2
Rdc47 P1B ndc47_1 0.412399665924
Ldc47 ndc47_1 dc2 1.67810314809e-07
* DC[48] P1B-dc3
Rdc48 P1B ndc48_1 7.89409980361
Ldc48 ndc48_1 dc3 3.16901948916e-06
* DC[51] P2B-P4B
Rdc51 P2B ndc51_1 5.57837796218
Ldc51 ndc51_1 P4B 1.67091236608e-06
* DC[52] P2B-dc0
Rdc52 P2B ndc52_1 0.304384271892
Ldc52 ndc52_1 dc0 1.10322535925e-07
* DC[53] P2B-dc1
Rdc53 P2B ndc53_1 15.0211568699
Ldc53 ndc53_1 dc1 7.6216655023e-06
* DC[54] P2B-dc2
Rdc54 P2B ndc54_1 0.22561464638
Ldc54 ndc54_1 dc2 8.38328530041e-08
* DC[55] P2B-dc3
Rdc55 P2B ndc55_1 0.196414961797
Ldc55 ndc55_1 dc3 7.35493352821e-08
* DC[56] P2B-P1B
Rdc56 P2B ndc56_1 0.653999944018
Ldc56 ndc56_1 P1B 2.55599394496e-07
* DC[57] P3B-P4B
Rdc57 P3B ndc57_1 0.133455185452
Ldc57 ndc57_1 P4B 5.46759572655e-08
* DC[62] P3B-P1B
Rdc62 P3B ndc62_1 14.0295566208
Ldc62 ndc62_1 P1B 2.60439654978e-06
* DC[69] dc0-dc2
Rdc69 dc0 ndc69_1 0.0250052755996
Ldc69 ndc69_1 dc2 2.96359798778e-08
* DC[71] dc0-P1B
Rdc71 dc0 ndc71_1 1.061903315
Ldc71 ndc71_1 P1B 4.39729052133e-07
* DC[73] dc1-dc3
Rdc73 dc1 ndc73_1 0.0598219625724
Ldc73 ndc73_1 dc3 9.68603429448e-08
* DC[74] dc1-P1B
Rdc74 dc1 ndc74_1 1.34059235041
Ldc74 ndc74_1 P1B 4.01464165659e-07
* DC[76] dc2-P1B
Rdc76 dc2 ndc76_1 0.605158773415
Ldc76 ndc76_1 P1B 2.4624628245e-07
* DC[77] dc3-P1B
Rdc77 dc3 ndc77_1 0.530740556544
Ldc77 ndc77_1 P1B 2.13061283591e-07
* ---- leaks
Rleak_P1A P1A P1B 1e+12
Rleak_P2A P2A P1B 1e+12
Rleak_P2B P2B P1B 1e+12
Rleak_P3A P3A P1B 1e+12
Rleak_P3B P3B P1B 1e+12
Rleak_P4A P4A P1B 1e+12
Rleak_P4B P4B P1B 1e+12
Rleak_dc0 dc0 P1B 1e+12
Rleak_dc1 dc1 P1B 1e+12
Rleak_dc2 dc2 P1B 1e+12
Rleak_dc3 dc3 P1B 1e+12
Rleak_rlc0 rlc0 P1B 1e+12
Rleak_rlc1 rlc1 P1B 1e+12
Rleak_rlc10 rlc10 P1B 1e+12
Rleak_rlc11 rlc11 P1B 1e+12
Rleak_rlc12 rlc12 P1B 1e+12
Rleak_rlc13 rlc13 P1B 1e+12
Rleak_rlc14 rlc14 P1B 1e+12
Rleak_rlc15 rlc15 P1B 1e+12
Rleak_rlc2 rlc2 P1B 1e+12
Rleak_rlc3 rlc3 P1B 1e+12
Rleak_rlc4 rlc4 P1B 1e+12
Rleak_rlc5 rlc5 P1B 1e+12
Rleak_rlc6 rlc6 P1B 1e+12
Rleak_rlc7 rlc7 P1B 1e+12
Rleak_rlc8 rlc8 P1B 1e+12
Rleak_rlc9 rlc9 P1B 1e+12
.ends fitted
