* fitted: 4-port fitted model, reference z0 = 50 Ohm
* port p is PpA (+) to PpB (-); the reference node is P1B
.subckt fitted P1A P1B P2A P2B P3A P3B P4A P4B
* ---- branches
* RLC[0] P1A-P2A
Rrlc0 P1A nrlc0_1 3.02319933839
Lrlc0 nrlc0_1 nrlc0_2 2.37307743253e-06
Crlc0 nrlc0_2 P2A 5.05730802456e-07
* RLC[1] P1A-P3A
Rrlc1 P1A nrlc1_1 231.746016306
Lrlc1 nrlc1_1 nrlc1_2 8.06667505617e-07
Crlc1 nrlc1_2 P3A 1.66888917893e-14
* RLC[2] P1A-P4A
Rrlc2 P1A nrlc2_1 4102789.30963
Lrlc2 nrlc2_1 nrlc2_2 0.0187754135433
Crlc2 nrlc2_2 P4A 7.99396909154e-16
* RLC[4] P1A-P2B
Rrlc4 P1A nrlc4_1 0.104468963958
Lrlc4 nrlc4_1 nrlc4_2 6.95888859021e-11
Crlc4 nrlc4_2 P2B 8.02964080571e-12
* RLC[5] P1A-P3B
Rrlc5 P1A nrlc5_1 841078.324454
Lrlc5 nrlc5_1 nrlc5_2 1
Crlc5 nrlc5_2 P3B 4.26724599368e-12
* RLC[7] P1A-rlc0
Rrlc7 P1A nrlc7_1 320.904395124
Lrlc7 nrlc7_1 nrlc7_2 2.02404134856e-06
Crlc7 nrlc7_2 rlc0 2.18386375447e-14
* RLC[13] P1A-rlc6
Rrlc13 P1A nrlc13_1 4788.57022892
Lrlc13 nrlc13_1 nrlc13_2 7.24610574167e-05
Crlc13 nrlc13_2 rlc6 3.51115850723e-15
* RLC[16] P1A-rlc9
Rrlc16 P1A nrlc16_1 116.813570565
Lrlc16 nrlc16_1 nrlc16_2 3.06075481667e-07
Crlc16 nrlc16_2 rlc9 2.49229493168e-14
* RLC[22] P1A-rlc15
Rrlc22 P1A nrlc22_1 1357.77155617
Lrlc22 nrlc22_1 nrlc22_2 1.26600989304e-05
Crlc22 nrlc22_2 rlc15 7.63029233426e-15
* RLC[24] P2A-P3A
Rrlc24 P2A nrlc24_1 1134111.41247
Lrlc24 nrlc24_1 nrlc24_2 0.00144946722102
Crlc24 nrlc24_2 P3A 5.20971213498e-15
* RLC[27] P2A-P2B
Rrlc27 P2A nrlc27_1 86.6651566564
Lrlc27 nrlc27_1 nrlc27_2 5.5146478076e-08
Crlc27 nrlc27_2 P2B 1.92529223526e-13
* RLC[31] P2A-rlc1
Rrlc31 P2A nrlc31_1 478485.348154
Lrlc31 nrlc31_1 nrlc31_2 0.111373799887
Crlc31 nrlc31_2 rlc1 9.03438802706e-13
* RLC[36] P2A-rlc6
Rrlc36 P2A nrlc36_1 4166.68333664
Lrlc36 nrlc36_1 nrlc36_2 5.09340100904e-05
Crlc36 nrlc36_2 rlc6 3.25975056256e-15
* RLC[39] P2A-rlc9
Rrlc39 P2A nrlc39_1 14526.0196323
Lrlc39 nrlc39_1 nrlc39_2 0.000138174284772
Crlc39 nrlc39_2 rlc9 7.27597942371e-16
* RLC[40] P2A-rlc10
Rrlc40 P2A nrlc40_1 10875.8160008
Lrlc40 nrlc40_1 nrlc40_2 1
Crlc40 nrlc40_2 rlc10 9.3936373009e-12
* RLC[41] P2A-rlc11
Rrlc41 P2A nrlc41_1 0.01
Lrlc41 nrlc41_1 nrlc41_2 1e-16
Crlc41 nrlc41_2 rlc11 5.5698236391e-12
* RLC[45] P2A-rlc15
Rrlc45 P2A nrlc45_1 186801.435905
Lrlc45 nrlc45_1 nrlc45_2 0.0492309762889
Crlc45 nrlc45_2 rlc15 1.96621534478e-11
* RLC[47] P3A-P4A
Rrlc47 P3A nrlc47_1 5082.13654671
Lrlc47 nrlc47_1 nrlc47_2 5.17452974919e-05
Crlc47 nrlc47_2 P4A 2.22605412504e-15
* RLC[49] P3A-P2B
Rrlc49 P3A nrlc49_1 1369.26740733
Lrlc49 nrlc49_1 nrlc49_2 5.54450624082e-06
Crlc49 nrlc49_2 P2B 3.70902986941e-14
* RLC[51] P3A-P4B
Rrlc51 P3A nrlc51_1 4.28611699955
Lrlc51 nrlc51_1 nrlc51_2 1.33252653214e-08
Crlc51 nrlc51_2 P4B 8.05944826376e-13
* RLC[52] P3A-rlc0
Rrlc52 P3A nrlc52_1 246.222204125
Lrlc52 nrlc52_1 nrlc52_2 7.13859694922e-07
Crlc52 nrlc52_2 rlc0 1.30832585275e-14
* RLC[54] P3A-rlc2
Rrlc54 P3A nrlc54_1 10931.1168703
Lrlc54 nrlc54_1 nrlc54_2 5.82994181927e-05
Crlc54 nrlc54_2 rlc2 8.98042073477e-14
* RLC[56] P3A-rlc4
Rrlc56 P3A nrlc56_1 977.702672448
Lrlc56 nrlc56_1 nrlc56_2 1.73323983887e-07
Crlc56 nrlc56_2 rlc4 1.98382115791e-14
* RLC[57] P3A-rlc5
Rrlc57 P3A nrlc57_1 1516.23432444
Lrlc57 nrlc57_1 nrlc57_2 1.20400087485e-05
Crlc57 nrlc57_2 rlc5 1.7245171836e-14
* RLC[60] P3A-rlc8
Rrlc60 P3A nrlc60_1 4.88030326169
Lrlc60 nrlc60_1 nrlc60_2 4.97367615985e-08
Crlc60 nrlc60_2 rlc8 2.32028522952e-12
* RLC[61] P3A-rlc9
Rrlc61 P3A nrlc61_1 2.57209323015
Lrlc61 nrlc61_1 nrlc61_2 3.74435478099e-08
Crlc61 nrlc61_2 rlc9 6.28870278532e-12
* RLC[62] P3A-rlc10
Rrlc62 P3A nrlc62_1 0.130019509475
Lrlc62 nrlc62_1 nrlc62_2 1.34445646611e-13
Crlc62 nrlc62_2 rlc10 8.83664052609e-15
* RLC[64] P3A-rlc12
Rrlc64 P3A nrlc64_1 2498.74364914
Lrlc64 nrlc64_1 nrlc64_2 3.91650239486e-05
Crlc64 nrlc64_2 rlc12 6.96967424899e-15
* RLC[65] P3A-rlc13
Rrlc65 P3A nrlc65_1 4930.83153459
Lrlc65 nrlc65_1 nrlc65_2 0.00022458702589
Crlc65 nrlc65_2 rlc13 1.02636497918e-14
* RLC[66] P3A-rlc14
Rrlc66 P3A nrlc66_1 370.537186467
Lrlc66 nrlc66_1 nrlc66_2 4.51249712871e-06
Crlc66 nrlc66_2 rlc14 3.65183233757e-14
* RLC[67] P3A-rlc15
Rrlc67 P3A nrlc67_1 2.25432005967
Lrlc67 nrlc67_1 nrlc67_2 3.13056926601e-09
Crlc67 nrlc67_2 rlc15 6.84462496155e-13
* RLC[68] P3A-P1B
Rrlc68 P3A nrlc68_1 330.835040312
Lrlc68 nrlc68_1 nrlc68_2 1.11415774038e-06
Crlc68 nrlc68_2 P1B 1.13104834691e-14
* RLC[69] P4A-P1B
Rrlc69 P4A nrlc69_1 129620.50038
Lrlc69 nrlc69_1 nrlc69_2 0.980439315745
Crlc69 nrlc69_2 P1B 9.11265495248e-05
* RLC[70] P4A-P2B
Rrlc70 P4A nrlc70_1 1708.14751931
Lrlc70 nrlc70_1 nrlc70_2 1.1657569718e-05
Crlc70 nrlc70_2 P2B 1.75807799696e-14
* RLC[71] P4A-P3B
Rrlc71 P4A nrlc71_1 2.27055024719
Lrlc71 nrlc71_1 nrlc71_2 3.38398863408e-08
Crlc71 nrlc71_2 P3B 7.29330123731e-12
* RLC[72] P4A-P4B
Rrlc72 P4A nrlc72_1 5.85858832597
Lrlc72 nrlc72_1 nrlc72_2 1.93014249004e-08
Crlc72 nrlc72_2 P4B 6.24828597256e-13
* RLC[74] P4A-rlc1
Rrlc74 P4A nrlc74_1 8.41746765766
Lrlc74 nrlc74_1 nrlc74_2 6.47177731713e-08
Crlc74 nrlc74_2 rlc1 1.01488806046e-12
* RLC[75] P4A-rlc2
Rrlc75 P4A nrlc75_1 230933.258574
Lrlc75 nrlc75_1 nrlc75_2 0.00095858293333
Crlc75 nrlc75_2 rlc2 2.19342524615e-13
* RLC[78] P4A-rlc5
Rrlc78 P4A nrlc78_1 1372.06555406
Lrlc78 nrlc78_1 nrlc78_2 1.4383978375e-06
Crlc78 nrlc78_2 rlc5 5.51532963893e-15
* RLC[79] P4A-rlc6
Rrlc79 P4A nrlc79_1 298.915892883
Lrlc79 nrlc79_1 nrlc79_2 9.37404360839e-07
Crlc79 nrlc79_2 rlc6 1.16569906279e-14
* RLC[80] P4A-rlc7
Rrlc80 P4A nrlc80_1 15.0402157353
Lrlc80 nrlc80_1 nrlc80_2 4.19150390689e-08
Crlc80 nrlc80_2 rlc7 2.05882405721e-13
* RLC[81] P4A-rlc8
Rrlc81 P4A nrlc81_1 514578.086178
Lrlc81 nrlc81_1 nrlc81_2 0.0172811794237
Crlc81 nrlc81_2 rlc8 9.42474244474e-12
* RLC[83] P4A-rlc10
Rrlc83 P4A nrlc83_1 127575.078862
Lrlc83 nrlc83_1 nrlc83_2 0.00435858687977
Crlc83 nrlc83_2 rlc10 1.0007365343e-10
* RLC[84] P4A-rlc11
Rrlc84 P4A nrlc84_1 1945.61431651
Lrlc84 nrlc84_1 nrlc84_2 3.46281120197e-06
Crlc84 nrlc84_2 rlc11 1.13810049823e-13
* RLC[85] P4A-rlc12
Rrlc85 P4A nrlc85_1 4741.01413876
Lrlc85 nrlc85_1 nrlc85_2 0.000248727807492
Crlc85 nrlc85_2 rlc12 1.22953057023e-14
* RLC[86] P4A-rlc13
Rrlc86 P4A nrlc86_1 19.6330427144
Lrlc86 nrlc86_1 nrlc86_2 4.47123300916e-08
Crlc86 nrlc86_2 rlc13 1.28887135151e-13
* RLC[88] P4A-rlc15
Rrlc88 P4A nrlc88_1 8.25809661857
Lrlc88 nrlc88_1 nrlc88_2 2.62664280872e-08
Crlc88 nrlc88_2 rlc15 4.27955756208e-13
* RLC[90] P1B-P2B
Rrlc90 P1B nrlc90_1 3.47239710894
Lrlc90 nrlc90_1 nrlc90_2 7.50666363074e-07
Crlc90 nrlc90_2 P2B 1.5675599176e-07
* RLC[93] P1B-rlc0
Rrlc93 P1B nrlc93_1 0.717479414389
Lrlc93 nrlc93_1 nrlc93_2 1.29645555782e-08
Crlc93 nrlc93_2 rlc0 0.001
* RLC[94] P1B-rlc1
Rrlc94 P1B nrlc94_1 53.0531861167
Lrlc94 nrlc94_1 nrlc94_2 1.5043132674e-06
Crlc94 nrlc94_2 rlc1 5.93844632048e-13
* RLC[95] P1B-rlc2
Rrlc95 P1B nrlc95_1 861.958891535
Lrlc95 nrlc95_1 nrlc95_2 1.61612628803e-05
Crlc95 nrlc95_2 rlc2 2.45921192301e-13
* RLC[96] P1B-rlc3
Rrlc96 P1B nrlc96_1 139.392526402
Lrlc96 nrlc96_1 nrlc96_2 5.77975291681e-07
Crlc96 nrlc96_2 rlc3 4.50250652351e-12
* RLC[97] P1B-rlc4
Rrlc97 P1B nrlc97_1 0.469364013666
Lrlc97 nrlc97_1 nrlc97_2 3.48214366218e-09
Crlc97 nrlc97_2 rlc4 2.11954443677e-06
* RLC[98] P1B-rlc5
Rrlc98 P1B nrlc98_1 22.9970586947
Lrlc98 nrlc98_1 nrlc98_2 3.29183839932e-07
Crlc98 nrlc98_2 rlc5 2.72366467107e-12
* RLC[99] P1B-rlc6
Rrlc99 P1B nrlc99_1 269.706311129
Lrlc99 nrlc99_1 nrlc99_2 1.01087909876e-05
Crlc99 nrlc99_2 rlc6 1.544096681e-13
* RLC[101] P1B-rlc8
Rrlc101 P1B nrlc101_1 6.58073945724
Lrlc101 nrlc101_1 nrlc101_2 1.59193867665e-07
Crlc101 nrlc101_2 rlc8 4.08445796969e-12
* RLC[103] P1B-rlc10
Rrlc103 P1B nrlc103_1 42.0834681251
Lrlc103 nrlc103_1 nrlc103_2 4.50504964923e-07
Crlc103 nrlc103_2 rlc10 1.33583993705e-12
* RLC[105] P1B-rlc12
Rrlc105 P1B nrlc105_1 40.2406653194
Lrlc105 nrlc105_1 nrlc105_2 1.89737092221e-07
Crlc105 nrlc105_2 rlc12 2.51675032975e-13
* RLC[106] P1B-rlc13
Rrlc106 P1B nrlc106_1 5.75969292066
Lrlc106 nrlc106_1 nrlc106_2 3.46230475489e-07
Crlc106 nrlc106_2 rlc13 1.16422770668e-08
* RLC[111] P2B-P4B
Rrlc111 P2B nrlc111_1 4870.75159458
Lrlc111 nrlc111_1 nrlc111_2 4.90588328474e-05
Crlc111 nrlc111_2 P4B 1.83386059856e-14
* RLC[112] P2B-rlc0
Rrlc112 P2B nrlc112_1 187.792461822
Lrlc112 nrlc112_1 nrlc112_2 1.51322147449e-06
Crlc112 nrlc112_2 rlc0 4.76764242692e-14
* RLC[114] P2B-rlc2
Rrlc114 P2B nrlc114_1 3936.09328589
Lrlc114 nrlc114_1 nrlc114_2 6.20129073731e-05
Crlc114 nrlc114_2 rlc2 2.86712767159e-14
* RLC[115] P2B-rlc3
Rrlc115 P2B nrlc115_1 314.514376559
Lrlc115 nrlc115_1 nrlc115_2 2.95490771593e-05
Crlc115 nrlc115_2 rlc3 7.11955215351e-10
* RLC[117] P2B-rlc5
Rrlc117 P2B nrlc117_1 0.0323368149008
Lrlc117 nrlc117_1 nrlc117_2 1e-16
Crlc117 nrlc117_2 rlc5 4.22714561412e-12
* RLC[118] P2B-rlc6
Rrlc118 P2B nrlc118_1 5088.85057663
Lrlc118 nrlc118_1 nrlc118_2 2.59686566875e-05
Crlc118 nrlc118_2 rlc6 1.61525750436e-13
* RLC[122] P2B-rlc10
Rrlc122 P2B nrlc122_1 3422.32764614
Lrlc122 nrlc122_1 nrlc122_2 0.000103137582619
Crlc122 nrlc122_2 rlc10 9.78433395361e-15
* RLC[123] P2B-rlc11
Rrlc123 P2B nrlc123_1 6811.88280485
Lrlc123 nrlc123_1 nrlc123_2 0.000166438419272
Crlc123 nrlc123_2 rlc11 3.98544424601e-15
* RLC[124] P2B-rlc12
Rrlc124 P2B nrlc124_1 721.695216835
Lrlc124 nrlc124_1 nrlc124_2 1.00904137375e-05
Crlc124 nrlc124_2 rlc12 2.15257757041e-14
* RLC[126] P2B-rlc14
Rrlc126 P2B nrlc126_1 197.655091682
Lrlc126 nrlc126_1 nrlc126_2 1.43146216482e-06
Crlc126 nrlc126_2 rlc14 4.07118981417e-14
* RLC[129] P3B-P4B
Rrlc129 P3B nrlc129_1 0.822094552203
Lrlc129 nrlc129_1 nrlc129_2 2.55427621479e-09
Crlc129 nrlc129_2 P4B 4.19934745079e-12
* RLC[130] P3B-rlc0
Rrlc130 P3B nrlc130_1 0.0558989968886
Lrlc130 nrlc130_1 nrlc130_2 1.07392811413e-07
Crlc130 nrlc130_2 rlc0 1.3393679112e-06
* RLC[131] P3B-rlc1
Rrlc131 P3B nrlc131_1 6.22844966914
Lrlc131 nrlc131_1 nrlc131_2 1.11812853556e-08
Crlc131 nrlc131_2 rlc1 3.20250121383e-13
* RLC[132] P3B-rlc2
Rrlc132 P3B nrlc132_1 0.215370365106
Lrlc132 nrlc132_1 nrlc132_2 9.4259625269e-11
Crlc132 nrlc132_2 rlc2 2.25793435161e-12
* RLC[133] P3B-rlc3
Rrlc133 P3B nrlc133_1 0.085760314424
Lrlc133 nrlc133_1 nrlc133_2 7.12126519855e-08
Crlc133 nrlc133_2 rlc3 6.605326647e-06
* RLC[134] P3B-rlc4
Rrlc134 P3B nrlc134_1 0.287597540849
Lrlc134 nrlc134_1 nrlc134_2 1.25837839596e-07
Crlc134 nrlc134_2 rlc4 7.54185202628e-06
* RLC[135] P3B-rlc5
Rrlc135 P3B nrlc135_1 14704.7396666
Lrlc135 nrlc135_1 nrlc135_2 2.1171618002e-06
Crlc135 nrlc135_2 rlc5 3.38204884544e-11
* RLC[136] P3B-rlc6
Rrlc136 P3B nrlc136_1 672.16767863
Lrlc136 nrlc136_1 nrlc136_2 1.55310568014e-06
Crlc136 nrlc136_2 rlc6 2.95126380992e-14
* RLC[137] P3B-rlc7
Rrlc137 P3B nrlc137_1 34.4619138826
Lrlc137 nrlc137_1 nrlc137_2 5.53677808246e-06
Crlc137 nrlc137_2 rlc7 6.5781688787e-08
* RLC[139] P3B-rlc9
Rrlc139 P3B nrlc139_1 73.5312968589
Lrlc139 nrlc139_1 nrlc139_2 2.26259984524e-07
Crlc139 nrlc139_2 rlc9 4.64965566985e-14
* RLC[140] P3B-rlc10
Rrlc140 P3B nrlc140_1 4.77762254433
Lrlc140 nrlc140_1 nrlc140_2 1.85005978251e-08
Crlc140 nrlc140_2 rlc10 9.00574368378e-13
* RLC[144] P3B-rlc14
Rrlc144 P3B nrlc144_1 0.615618360971
Lrlc144 nrlc144_1 nrlc144_2 1.13001227258e-06
Crlc144 nrlc144_2 rlc14 3.31297014452e-09
* RLC[145] P3B-rlc15
Rrlc145 P3B nrlc145_1 931.248138419
Lrlc145 nrlc145_1 nrlc145_2 2.19604772211e-05
Crlc145 nrlc145_2 rlc15 2.81363934813e-14
* RLC[147] P4B-rlc0
Rrlc147 P4B nrlc147_1 9.09840067512
Lrlc147 nrlc147_1 nrlc147_2 7.7835867394e-07
Crlc147 nrlc147_2 rlc0 2.13148041031e-05
* RLC[148] P4B-rlc1
Rrlc148 P4B nrlc148_1 3401.91971509
Lrlc148 nrlc148_1 nrlc148_2 8.26240866264e-05
Crlc148 nrlc148_2 rlc1 7.9326088831e-15
* RLC[151] P4B-rlc4
Rrlc151 P4B nrlc151_1 2.45203561445
Lrlc151 nrlc151_1 nrlc151_2 1.44469848012e-06
Crlc151 nrlc151_2 rlc4 7.51922506772e-06
* RLC[152] P4B-rlc5
Rrlc152 P4B nrlc152_1 5551.30982374
Lrlc152 nrlc152_1 nrlc152_2 4.05217285904e-06
Crlc152 nrlc152_2 rlc5 0.000857950737947
* RLC[153] P4B-rlc6
Rrlc153 P4B nrlc153_1 13.7380428507
Lrlc153 nrlc153_1 nrlc153_2 5.88079763199e-08
Crlc153 nrlc153_2 rlc6 3.46213494948e-13
* RLC[156] P4B-rlc9
Rrlc156 P4B nrlc156_1 0.01
Lrlc156 nrlc156_1 nrlc156_2 5.24778357389e-10
Crlc156 nrlc156_2 rlc9 0.001
* RLC[157] P4B-rlc10
Rrlc157 P4B nrlc157_1 0.01
Lrlc157 nrlc157_1 nrlc157_2 1.31244015412e-05
Crlc157 nrlc157_2 rlc10 0.001
* RLC[159] P4B-rlc12
Rrlc159 P4B nrlc159_1 738.362917744
Lrlc159 nrlc159_1 nrlc159_2 2.70199364638e-06
Crlc159 nrlc159_2 rlc12 2.04259059023e-11
* RLC[160] P4B-rlc13
Rrlc160 P4B nrlc160_1 1303.03964709
Lrlc160 nrlc160_1 nrlc160_2 1.41323931179e-05
Crlc160 nrlc160_2 rlc13 6.53858083071e-14
* RLC[161] P4B-rlc14
Rrlc161 P4B nrlc161_1 1431.1663823
Lrlc161 nrlc161_1 nrlc161_2 1.53650414811e-05
Crlc161 nrlc161_2 rlc14 8.33510308137e-15
* RLC[162] P4B-rlc15
Rrlc162 P4B nrlc162_1 1916.65275454
Lrlc162 nrlc162_1 nrlc162_2 1.04209873209e-05
Crlc162 nrlc162_2 rlc15 3.90709850334e-13
* RLC[164] rlc0-rlc1
Rrlc164 rlc0 nrlc164_1 36.6251495142
Lrlc164 nrlc164_1 nrlc164_2 7.55902015676e-08
Crlc164 nrlc164_2 rlc1 6.26129522261e-14
* RLC[165] rlc0-rlc2
Rrlc165 rlc0 nrlc165_1 46.0540003098
Lrlc165 nrlc165_1 nrlc165_2 7.50833073022e-07
Crlc165 nrlc165_2 rlc2 3.93338236044e-13
* RLC[169] rlc0-rlc6
Rrlc169 rlc0 nrlc169_1 17.5446957152
Lrlc169 nrlc169_1 nrlc169_2 2.71582186578e-08
Crlc169 nrlc169_2 rlc6 9.80318255681e-14
* RLC[170] rlc0-rlc7
Rrlc170 rlc0 nrlc170_1 6.74544185448
Lrlc170 nrlc170_1 nrlc170_2 4.48507255825e-08
Crlc170 nrlc170_2 rlc7 1.09523208446e-12
* RLC[171] rlc0-rlc8
Rrlc171 rlc0 nrlc171_1 313.480227748
Lrlc171 nrlc171_1 nrlc171_2 0.0147734716936
Crlc171 nrlc171_2 rlc8 2.19948692746e-10
* RLC[173] rlc0-rlc10
Rrlc173 rlc0 nrlc173_1 5.50705435373
Lrlc173 nrlc173_1 nrlc173_2 2.25055315404e-08
Crlc173 nrlc173_2 rlc10 4.13094754425e-11
* RLC[177] rlc0-rlc14
Rrlc177 rlc0 nrlc177_1 147.667299221
Lrlc177 nrlc177_1 nrlc177_2 1.72706195868e-06
Crlc177 nrlc177_2 rlc14 8.80028516056e-14
* RLC[178] rlc0-rlc15
Rrlc178 rlc0 nrlc178_1 451.005259609
Lrlc178 nrlc178_1 nrlc178_2 7.35845689436e-06
Crlc178 nrlc178_2 rlc15 4.01958324643e-14
* RLC[179] rlc0-P1B
Rrlc179 rlc0 nrlc179_1 4.28133996639
Lrlc179 nrlc179_1 nrlc179_2 2.78728594277e-08
Crlc179 nrlc179_2 P1B 2.74532015325e-12
* RLC[180] rlc1-rlc2
Rrlc180 rlc1 nrlc180_1 3.33671255397
Lrlc180 nrlc180_1 nrlc180_2 8.6910084652e-08
Crlc180 nrlc180_2 rlc2 8.67341392374e-12
* RLC[181] rlc1-rlc3
Rrlc181 rlc1 nrlc181_1 263.718224549
Lrlc181 nrlc181_1 nrlc181_2 2.07941890438e-06
Crlc181 nrlc181_2 rlc3 5.58939403812e-12
* RLC[182] rlc1-rlc4
Rrlc182 rlc1 nrlc182_1 629.52076809
Lrlc182 nrlc182_1 nrlc182_2 7.45909669296e-06
Crlc182 nrlc182_2 rlc4 1.25695229891e-12
* RLC[183] rlc1-rlc5
Rrlc183 rlc1 nrlc183_1 697.468324218
Lrlc183 nrlc183_1 nrlc183_2 2.72487715933e-05
Crlc183 nrlc183_2 rlc5 6.22379732489e-14
* RLC[184] rlc1-rlc6
Rrlc184 rlc1 nrlc184_1 2.78875562862
Lrlc184 nrlc184_1 nrlc184_2 1.72577846956e-07
Crlc184 nrlc184_2 rlc6 2.46559430021e-11
* RLC[185] rlc1-rlc7
Rrlc185 rlc1 nrlc185_1 55.4821356925
Lrlc185 nrlc185_1 nrlc185_2 9.36211015103e-07
Crlc185 nrlc185_2 rlc7 1.87881520426e-12
* RLC[186] rlc1-rlc8
Rrlc186 rlc1 nrlc186_1 1.146818053
Lrlc186 nrlc186_1 nrlc186_2 9.92160124011e-09
Crlc186 nrlc186_2 rlc8 8.382049419e-12
* RLC[187] rlc1-rlc9
Rrlc187 rlc1 nrlc187_1 1259.57412231
Lrlc187 nrlc187_1 nrlc187_2 4.68903150552e-05
Crlc187 nrlc187_2 rlc9 0.000120370238151
* RLC[188] rlc1-rlc10
Rrlc188 rlc1 nrlc188_1 2851.44606453
Lrlc188 nrlc188_1 nrlc188_2 3.68110557062e-05
Crlc188 nrlc188_2 rlc10 1.94495466191e-09
* RLC[190] rlc1-rlc12
Rrlc190 rlc1 nrlc190_1 74.2610111304
Lrlc190 nrlc190_1 nrlc190_2 4.43884893438e-07
Crlc190 nrlc190_2 rlc12 0.000113317723069
* RLC[191] rlc1-rlc13
Rrlc191 rlc1 nrlc191_1 9.06805433941
Lrlc191 nrlc191_1 nrlc191_2 1.36721030914e-07
Crlc191 nrlc191_2 rlc13 3.63584443131e-12
* RLC[192] rlc1-rlc14
Rrlc192 rlc1 nrlc192_1 159.053062183
Lrlc192 nrlc192_1 nrlc192_2 2.21399140904e-06
Crlc192 nrlc192_2 rlc14 9.72409856513e-14
* RLC[194] rlc1-P1B
Rrlc194 rlc1 nrlc194_1 258.477011799
Lrlc194 nrlc194_1 nrlc194_2 1.11788715957e-06
Crlc194 nrlc194_2 P1B 3.35453506856e-12
* RLC[195] rlc2-rlc3
Rrlc195 rlc2 nrlc195_1 0.153146917054
Lrlc195 nrlc195_1 nrlc195_2 0.0174003084892
Crlc195 nrlc195_2 rlc3 0.000824323990248
* RLC[196] rlc2-rlc4
Rrlc196 rlc2 nrlc196_1 15639.0324996
Lrlc196 nrlc196_1 nrlc196_2 0.0335375404414
Crlc196 nrlc196_2 rlc4 3.8174952515e-11
* RLC[197] rlc2-rlc5
Rrlc197 rlc2 nrlc197_1 59.510050379
Lrlc197 nrlc197_1 nrlc197_2 0.00191472106691
Crlc197 nrlc197_2 rlc5 6.00734477791e-10
* RLC[199] rlc2-rlc7
Rrlc199 rlc2 nrlc199_1 8678.90740554
Lrlc199 nrlc199_1 nrlc199_2 0.00101317733646
Crlc199 nrlc199_2 rlc7 2.48321725606e-11
* RLC[200] rlc2-rlc8
Rrlc200 rlc2 nrlc200_1 0.0610492935531
Lrlc200 nrlc200_1 nrlc200_2 2.99217210908e-11
Crlc200 nrlc200_2 rlc8 8.9203680899e-12
* RLC[203] rlc2-rlc11
Rrlc203 rlc2 nrlc203_1 250.635552307
Lrlc203 nrlc203_1 nrlc203_2 3.62296304797e-06
Crlc203 nrlc203_2 rlc11 6.40819981188e-14
* RLC[205] rlc2-rlc13
Rrlc205 rlc2 nrlc205_1 3065.0088141
Lrlc205 nrlc205_1 nrlc205_2 3.73666176519e-05
Crlc205 nrlc205_2 rlc13 5.019955294e-11
* RLC[206] rlc2-rlc14
Rrlc206 rlc2 nrlc206_1 11283.6197844
Lrlc206 nrlc206_1 nrlc206_2 0.000322477450494
Crlc206 nrlc206_2 rlc14 1.21791554002e-11
* RLC[207] rlc2-rlc15
Rrlc207 rlc2 nrlc207_1 2357.70522006
Lrlc207 nrlc207_1 nrlc207_2 0.000239042599939
Crlc207 nrlc207_2 rlc15 0.000147116672213
* RLC[208] rlc2-P1B
Rrlc208 rlc2 nrlc208_1 8457.52124232
Lrlc208 nrlc208_1 nrlc208_2 0.00205618277503
Crlc208 nrlc208_2 P1B 4.42831983923e-11
* RLC[209] rlc3-rlc4
Rrlc209 rlc3 nrlc209_1 105.355384088
Lrlc209 nrlc209_1 nrlc209_2 5.57669464791e-07
Crlc209 nrlc209_2 rlc4 6.27564638174e-12
* RLC[210] rlc3-rlc5
Rrlc210 rlc3 nrlc210_1 16.2192691667
Lrlc210 nrlc210_1 nrlc210_2 3.00456565929e-07
Crlc210 nrlc210_2 rlc5 1.26904384579e-12
* RLC[211] rlc3-rlc6
Rrlc211 rlc3 nrlc211_1 97.1348073147
Lrlc211 nrlc211_1 nrlc211_2 9.07656125557e-07
Crlc211 nrlc211_2 rlc6 1.06888028675e-13
* RLC[212] rlc3-rlc7
Rrlc212 rlc3 nrlc212_1 11.4988928347
Lrlc212 nrlc212_1 nrlc212_2 1.03685299494e-07
Crlc212 nrlc212_2 rlc7 8.71289788131e-13
* RLC[213] rlc3-rlc8
Rrlc213 rlc3 nrlc213_1 50.6938881949
Lrlc213 nrlc213_1 nrlc213_2 9.4846566979e-07
Crlc213 nrlc213_2 rlc8 4.10079350729e-13
* RLC[214] rlc3-rlc9
Rrlc214 rlc3 nrlc214_1 1659.43764089
Lrlc214 nrlc214_1 nrlc214_2 6.52817353638e-05
Crlc214 nrlc214_2 rlc9 2.63406997101e-14
* RLC[215] rlc3-rlc10
Rrlc215 rlc3 nrlc215_1 11.6390900067
Lrlc215 nrlc215_1 nrlc215_2 1.11673979973e-07
Crlc215 nrlc215_2 rlc10 9.1594929257e-13
* RLC[217] rlc3-rlc12
Rrlc217 rlc3 nrlc217_1 8250.50112276
Lrlc217 nrlc217_1 nrlc217_2 7.35916057095e-05
Crlc217 nrlc217_2 rlc12 9.342764951e-11
* RLC[218] rlc3-rlc13
Rrlc218 rlc3 nrlc218_1 0.376017811664
Lrlc218 nrlc218_1 nrlc218_2 1.45423599634e-08
Crlc218 nrlc218_2 rlc13 1.41245959838e-05
* RLC[219] rlc3-rlc14
Rrlc219 rlc3 nrlc219_1 7.35195853218
Lrlc219 nrlc219_1 nrlc219_2 7.80441618367e-08
Crlc219 nrlc219_2 rlc14 1.60432301508e-12
* RLC[220] rlc3-rlc15
Rrlc220 rlc3 nrlc220_1 4.0431921347
Lrlc220 nrlc220_1 nrlc220_2 5.25183986116e-08
Crlc220 nrlc220_2 rlc15 3.56961888426e-12
* RLC[221] rlc3-P1B
Rrlc221 rlc3 nrlc221_1 55.0544064493
Lrlc221 nrlc221_1 nrlc221_2 8.11148588467e-07
Crlc221 nrlc221_2 P1B 3.73720099063e-13
* RLC[223] rlc4-rlc6
Rrlc223 rlc4 nrlc223_1 1538.25596651
Lrlc223 nrlc223_1 nrlc223_2 3.0655293912e-05
Crlc223 nrlc223_2 rlc6 2.05444860378e-10
* RLC[224] rlc4-rlc7
Rrlc224 rlc4 nrlc224_1 0.0115251715658
Lrlc224 nrlc224_1 nrlc224_2 3.15219867766e-09
Crlc224 nrlc224_2 rlc7 2.63679444379e-08
* RLC[225] rlc4-rlc8
Rrlc225 rlc4 nrlc225_1 138.644677565
Lrlc225 nrlc225_1 nrlc225_2 4.52162318638e-06
Crlc225 nrlc225_2 rlc8 2.61363810712e-13
* RLC[226] rlc4-rlc9
Rrlc226 rlc4 nrlc226_1 7.53447619234
Lrlc226 nrlc226_1 nrlc226_2 3.16489989399e-06
Crlc226 nrlc226_2 rlc9 7.55788081268e-08
* RLC[227] rlc4-rlc10
Rrlc227 rlc4 nrlc227_1 21.5198201267
Lrlc227 nrlc227_1 nrlc227_2 2.53471149853e-06
Crlc227 nrlc227_2 rlc10 3.91284273978e-08
* RLC[228] rlc4-rlc11
Rrlc228 rlc4 nrlc228_1 713.367341982
Lrlc228 nrlc228_1 nrlc228_2 4.54266102582e-06
Crlc228 nrlc228_2 rlc11 9.91839441857e-15
* RLC[229] rlc4-rlc12
Rrlc229 rlc4 nrlc229_1 56.6897795095
Lrlc229 nrlc229_1 nrlc229_2 1.80125208703e-06
Crlc229 nrlc229_2 rlc12 6.2276249786e-13
* RLC[230] rlc4-rlc13
Rrlc230 rlc4 nrlc230_1 81.7860297038
Lrlc230 nrlc230_1 nrlc230_2 1.92731663756e-06
Crlc230 nrlc230_2 rlc13 3.20149117638e-13
* RLC[231] rlc4-rlc14
Rrlc231 rlc4 nrlc231_1 3.25480845398
Lrlc231 nrlc231_1 nrlc231_2 2.68589997183e-08
Crlc231 nrlc231_2 rlc14 2.81706231877e-12
* RLC[232] rlc4-rlc15
Rrlc232 rlc4 nrlc232_1 2.74666525995
Lrlc232 nrlc232_1 nrlc232_2 4.88057467384e-08
Crlc232 nrlc232_2 rlc15 7.18815815746e-12
* RLC[233] rlc4-P1B
Rrlc233 rlc4 nrlc233_1 1.29424547726
Lrlc233 nrlc233_1 nrlc233_2 9.75352748523e-09
Crlc233 nrlc233_2 P1B 1.76361948074e-10
* RLC[234] rlc5-rlc6
Rrlc234 rlc5 nrlc234_1 80.9097612841
Lrlc234 nrlc234_1 nrlc234_2 1.72900238646e-06
Crlc234 nrlc234_2 rlc6 2.93461574694e-13
* RLC[235] rlc5-rlc7
Rrlc235 rlc5 nrlc235_1 0.899381822646
Lrlc235 nrlc235_1 nrlc235_2 1.91274320674e-08
Crlc235 nrlc235_2 rlc7 2.62739849694e-11
* RLC[236] rlc5-rlc8
Rrlc236 rlc5 nrlc236_1 2038.77671521
Lrlc236 nrlc236_1 nrlc236_2 1.37091419499e-05
Crlc236 nrlc236_2 rlc8 2.31374527006e-13
* RLC[237] rlc5-rlc9
Rrlc237 rlc5 nrlc237_1 21169.5979795
Lrlc237 nrlc237_1 nrlc237_2 1.3905250074e-05
Crlc237 nrlc237_2 rlc9 9.45513193842e-14
* RLC[238] rlc5-rlc10
Rrlc238 rlc5 nrlc238_1 0.150245719987
Lrlc238 nrlc238_1 nrlc238_2 0.00375860326256
Crlc238 nrlc238_2 rlc10 0.000185003420695
* RLC[239] rlc5-rlc11
Rrlc239 rlc5 nrlc239_1 0.0171505053861
Lrlc239 nrlc239_1 nrlc239_2 1.684799788e-08
Crlc239 nrlc239_2 rlc11 6.36431908128e-08
* RLC[241] rlc5-rlc13
Rrlc241 rlc5 nrlc241_1 844.090089627
Lrlc241 nrlc241_1 nrlc241_2 1.9761920155e-05
Crlc241 nrlc241_2 rlc13 3.08183248194e-14
* RLC[242] rlc5-rlc14
Rrlc242 rlc5 nrlc242_1 895.348564048
Lrlc242 nrlc242_1 nrlc242_2 1.35678095245e-06
Crlc242 nrlc242_2 rlc14 2.6714615167e-14
* RLC[243] rlc5-rlc15
Rrlc243 rlc5 nrlc243_1 0.0688932122361
Lrlc243 nrlc243_1 nrlc243_2 0.00427164722298
Crlc243 nrlc243_2 rlc15 0.001
* RLC[244] rlc5-P1B
Rrlc244 rlc5 nrlc244_1 146.760809846
Lrlc244 nrlc244_1 nrlc244_2 4.50171930778e-06
Crlc244 nrlc244_2 P1B 2.68463924768e-13
* RLC[247] rlc6-rlc9
Rrlc247 rlc6 nrlc247_1 0.365754190739
Lrlc247 nrlc247_1 nrlc247_2 0.000121619374783
Crlc247 nrlc247_2 rlc9 8.96716050571e-05
* RLC[248] rlc6-rlc10
Rrlc248 rlc6 nrlc248_1 335.116164224
Lrlc248 nrlc248_1 nrlc248_2 2.37351447948e-06
Crlc248 nrlc248_2 rlc10 7.7999250209e-12
* RLC[250] rlc6-rlc12
Rrlc250 rlc6 nrlc250_1 12.3944234205
Lrlc250 nrlc250_1 nrlc250_2 1.08077798388e-07
Crlc250 nrlc250_2 rlc12 7.8170217942e-13
* RLC[252] rlc6-rlc14
Rrlc252 rlc6 nrlc252_1 25.3530876243
Lrlc252 nrlc252_1 nrlc252_2 2.4432550172e-07
Crlc252 nrlc252_2 rlc14 4.22342294458e-13
* RLC[253] rlc6-rlc15
Rrlc253 rlc6 nrlc253_1 18.0101125687
Lrlc253 nrlc253_1 nrlc253_2 2.32560883354e-07
Crlc253 nrlc253_2 rlc15 7.96638524113e-13
* RLC[254] rlc6-P1B
Rrlc254 rlc6 nrlc254_1 1079.57470574
Lrlc254 nrlc254_1 nrlc254_2 1.67964582944e-05
Crlc254 nrlc254_2 P1B 4.78024517758e-13
* RLC[256] rlc7-rlc9
Rrlc256 rlc7 nrlc256_1 22.5240046847
Lrlc256 nrlc256_1 nrlc256_2 1.05622344904e-07
Crlc256 nrlc256_2 rlc9 2.31324737239e-13
* RLC[257] rlc7-rlc10
Rrlc257 rlc7 nrlc257_1 0.050139393754
Lrlc257 nrlc257_1 nrlc257_2 1.28141014975e-08
Crlc257 nrlc257_2 rlc10 5.66353375349e-09
* RLC[258] rlc7-rlc11
Rrlc258 rlc7 nrlc258_1 770.850018487
Lrlc258 nrlc258_1 nrlc258_2 7.12619144913e-06
Crlc258 nrlc258_2 rlc11 1.33252449757e-14
* RLC[260] rlc7-rlc13
Rrlc260 rlc7 nrlc260_1 58.2339462518
Lrlc260 nrlc260_1 nrlc260_2 2.3068346952e-07
Crlc260 nrlc260_2 rlc13 9.81341344951e-14
* RLC[263] rlc7-P1B
Rrlc263 rlc7 nrlc263_1 9.3400394066
Lrlc263 nrlc263_1 nrlc263_2 8.1774498379e-08
Crlc263 nrlc263_2 P1B 5.79016624631e-12
* RLC[264] rlc8-rlc9
Rrlc264 rlc8 nrlc264_1 1465.2213412
Lrlc264 nrlc264_1 nrlc264_2 0.000108110963863
Crlc264 nrlc264_2 rlc9 3.33215905416e-05
* RLC[265] rlc8-rlc10
Rrlc265 rlc8 nrlc265_1 5097.20444517
Lrlc265 nrlc265_1 nrlc265_2 4.50135695766e-05
Crlc265 nrlc265_2 rlc10 4.00925710453e-11
* RLC[266] rlc8-rlc11
Rrlc266 rlc8 nrlc266_1 659.383549435
Lrlc266 nrlc266_1 nrlc266_2 1.39946835453e-05
Crlc266 nrlc266_2 rlc11 3.57638576017e-14
* RLC[267] rlc8-rlc12
Rrlc267 rlc8 nrlc267_1 267.45240134
Lrlc267 nrlc267_1 nrlc267_2 7.83980577499e-07
Crlc267 nrlc267_2 rlc12 7.29856329813e-10
* RLC[271] rlc8-P1B
Rrlc271 rlc8 nrlc271_1 1041.44557746
Lrlc271 nrlc271_1 nrlc271_2 4.23643499294e-06
Crlc271 nrlc271_2 P1B 5.40858638065e-10
* RLC[272] rlc9-rlc10
Rrlc272 rlc9 nrlc272_1 4.10126870235
Lrlc272 nrlc272_1 nrlc272_2 1.69191751263e-08
Crlc272 nrlc272_2 rlc10 1.1176356044e-12
* RLC[275] rlc9-rlc13
Rrlc275 rlc9 nrlc275_1 0.03158381601
Lrlc275 nrlc275_1 nrlc275_2 7.07308361167e-08
Crlc275 nrlc275_2 rlc13 0.001
* RLC[277] rlc9-rlc15
Rrlc277 rlc9 nrlc277_1 1241.11962125
Lrlc277 nrlc277_1 nrlc277_2 8.16759274864e-06
Crlc277 nrlc277_2 rlc15 6.25868097697e-15
* RLC[280] rlc10-rlc12
Rrlc280 rlc10 nrlc280_1 36.0909125343
Lrlc280 nrlc280_1 nrlc280_2 2.82344569039e-07
Crlc280 nrlc280_2 rlc12 2.40846978808e-13
* RLC[281] rlc10-rlc13
Rrlc281 rlc10 nrlc281_1 237.682398005
Lrlc281 nrlc281_1 nrlc281_2 5.6100357082e-06
Crlc281 nrlc281_2 rlc13 1.1033900802e-13
* RLC[282] rlc10-rlc14
Rrlc282 rlc10 nrlc282_1 109.499909541
Lrlc282 nrlc282_1 nrlc282_2 4.58694757686e-10
Crlc282 nrlc282_2 rlc14 1.35105306898e-13
* RLC[284] rlc10-P1B
Rrlc284 rlc10 nrlc284_1 9.32085434319
Lrlc284 nrlc284_1 nrlc284_2 1.46748714566e-07
Crlc284 nrlc284_2 P1B 1.8768135033e-12
* RLC[285] rlc11-rlc12
Rrlc285 rlc11 nrlc285_1 35149.6352576
Lrlc285 nrlc285_1 nrlc285_2 0.000244995361046
Crlc285 nrlc285_2 rlc12 1.23835327041e-11
* RLC[286] rlc11-rlc13
Rrlc286 rlc11 nrlc286_1 112.533198759
Lrlc286 nrlc286_1 nrlc286_2 0.0141160683517
Crlc286 nrlc286_2 rlc13 1.23853965277e-09
* RLC[288] rlc11-rlc15
Rrlc288 rlc11 nrlc288_1 2902.0022662
Lrlc288 nrlc288_1 nrlc288_2 2.30641574254e-08
Crlc288 nrlc288_2 rlc15 7.99982607975e-15
* RLC[289] rlc11-P1B
Rrlc289 rlc11 nrlc289_1 0.01
Lrlc289 nrlc289_1 nrlc289_2 1e-16
Crlc289 nrlc289_2 P1B 1.07027342628e-12
* RLC[290] rlc12-rlc13
Rrlc290 rlc12 nrlc290_1 22543.5849327
Lrlc290 nrlc290_1 nrlc290_2 0.000239645497039
Crlc290 nrlc290_2 rlc13 6.46934852965e-06
* RLC[291] rlc12-rlc14
Rrlc291 rlc12 nrlc291_1 64189.9785084
Lrlc291 nrlc291_1 nrlc291_2 0.000223445538705
Crlc291 nrlc291_2 rlc14 4.69757903081e-08
* RLC[292] rlc12-rlc15
Rrlc292 rlc12 nrlc292_1 0.289010091212
Lrlc292 nrlc292_1 nrlc292_2 6.905506294e-08
Crlc292 nrlc292_2 rlc15 9.18601186214e-10
* RLC[293] rlc12-P1B
Rrlc293 rlc12 nrlc293_1 23.4982368432
Lrlc293 nrlc293_1 nrlc293_2 9.50660579892e-07
Crlc293 nrlc293_2 P1B 1.91299060651e-12
* RLC[298] rlc14-P1B
Rrlc298 rlc14 nrlc298_1 316.196986844
Lrlc298 nrlc298_1 nrlc298_2 6.11453360629e-07
Crlc298 nrlc298_2 P1B 1.7236746668e-10
* DC[0] P1A-P2A
Rdc0 P1A ndc0_1 0.0513634563569
Ldc0 ndc0_1 P2A 5.46253374865e-08
* DC[23] P3A-P4A
Rdc23 P3A ndc23_1 0.0586846385105
Ldc23 ndc23_1 P4A 7.12543154572e-08
* DC[42] P1B-P2B
Rdc42 P1B ndc42_1 0.192151223089
Ldc42 ndc42_1 P2B 7.7401138948e-08
* DC[43] P1B-P3B
Rdc43 P1B ndc43_1 0.171586619098
Ldc43 ndc43_1 P3B 1.81269831423e-07
* DC[44] P1B-P4B
Rdc44 P1B ndc44_1 0.0891472997439
Ldc44 ndc44_1 P4B 2.01795262255e-07
* DC[45] P1B-dc0
Rdc45 P1B ndc45_1 0.0806490430549
Ldc45 ndc45_1 dc0 5.87023153748e-08
* DC[46] P1B-dc1
Rdc46 P1B ndc46_1 0.0100138500331
Ldc46 ndc46_1 dc1 4.26791446596e-09
* DC[47] P1B-dc2
Rdc47 P1B ndc47_1 4.29068204454
Ldc47 ndc47_1 dc2 3.7607591315e-06
* DC[51] P2B-P4B
Rdc51 P2B ndc51_1 1.73624136799
Ldc51 ndc51_1 P4B 7.01939994381e-07
* DC[53] P2B-dc1
Rdc53 P2B ndc53_1 0.184406953057
Ldc53 ndc53_1 dc1 7.44864191847e-08
* DC[56] P2B-P1B
Rdc56 P2B ndc56_1 1.95598889863
Ldc56 ndc56_1 P1B 7.87899030674e-07
* DC[58] P3B-dc0
Rdc58 P3B ndc58_1 1.99041572157
Ldc58 ndc58_1 dc0 5.95799512276e-06
* DC[61] P3B-dc3
Rdc61 P3B ndc61_1 1.04716123299
Ldc61 ndc61_1 dc3 3.41878508898e-06
* DC[63] P4B-dc0
Rdc63 P4B ndc63_1 0.0454235222458
Ldc63 ndc63_1 dc0 1.67207294023e-07
* DC[64] P4B-dc1
Rdc64 P4B ndc64_1 0.159944576126
Ldc64 ndc64_1 dc1 3.71528154948e-07
* DC[65] P4B-dc2
Rdc65 P4B ndc65_1 0.106689971483
Ldc65 ndc65_1 dc2 4.62318136264e-07
* DC[66] P4B-dc3
Rdc66 P4B ndc66_1 0.0195506218021
Ldc66 ndc66_1 dc3 7.62507786036e-08
* DC[67] P4B-P1B
Rdc67 P4B ndc67_1 1.14509533747
Ldc67 ndc67_1 P1B 2.5926801573e-06
* DC[70] dc0-dc3
Rdc70 dc0 ndc70_1 0.0149556244573
Ldc70 ndc70_1 dc3 2.38241940682e-08
* DC[71] dc0-P1B
Rdc71 dc0 ndc71_1 0.0806490430549
Ldc71 ndc71_1 P1B 5.87023153748e-08
* DC[74] dc1-P1B
Rdc74 dc1 ndc74_1 0.139551564482
Ldc74 ndc74_1 P1B 8.77635025031e-08
* DC[75] dc2-dc3
Rdc75 dc2 ndc75_1 0.0114003980274
Ldc75 ndc75_1 dc3 8.17981333219e-09
* DC[76] dc2-P1B
Rdc76 dc2 ndc76_1 0.0521613206289
Ldc76 ndc76_1 P1B 4.54607692511e-08
* ---- leaks
Rleak_P1A P1A P1B 1e+12
Rleak_P2A P2A P1B 1e+12
Rleak_P2B P2B P1B 1e+12
Rleak_P3A P3A P1B 1e+12
Rleak_P3B P3B P1B 1e+12
Rleak_P4A P4A P1B 1e+12
Rleak_P4B P4B P1B 1e+12
Rleak_dc0 dc0 P1B 1e+12
Rleak_dc1 dc1 P1B 1e+12
Rleak_dc2 dc2 P1B 1e+12
Rleak_dc3 dc3 P1B 1e+12
Rleak_rlc0 rlc0 P1B 1e+12
Rleak_rlc1 rlc1 P1B 1e+12
Rleak_rlc10 rlc10 P1B 1e+12
Rleak_rlc11 rlc11 P1B 1e+12
Rleak_rlc12 rlc12 P1B 1e+12
Rleak_rlc13 rlc13 P1B 1e+12
Rleak_rlc14 rlc14 P1B 1e+12
Rleak_rlc15 rlc15 P1B 1e+12
Rleak_rlc2 rlc2 P1B 1e+12
Rleak_rlc3 rlc3 P1B 1e+12
Rleak_rlc4 rlc4 P1B 1e+12
Rleak_rlc5 rlc5 P1B 1e+12
Rleak_rlc6 rlc6 P1B 1e+12
Rleak_rlc7 rlc7 P1B 1e+12
Rleak_rlc8 rlc8 P1B 1e+12
Rleak_rlc9 rlc9 P1B 1e+12
.ends fitted
