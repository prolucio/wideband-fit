* fitted: 4-port fitted model, reference z0 = 50 Ohm
* port p is PpA (+) to PpB (-); the reference node is P1B
.subckt fitted P1A P1B P2A P2B P3A P3B P4A P4B
* ---- branches
* RLC[2] P1A-P4A
Rrlc2 P1A nrlc2_1 1453.88458842
Lrlc2 nrlc2_1 nrlc2_2 2.37533220194e-07
Crlc2 nrlc2_2 P4A 1.3285900104e-14
* RLC[7] P1A-rlc0
Rrlc7 P1A nrlc7_1 601.690048562
Lrlc7 nrlc7_1 nrlc7_2 2.96563116851e-06
Crlc7 nrlc7_2 rlc0 9.10183525896e-15
* RLC[9] P1A-rlc2
Rrlc9 P1A nrlc9_1 5.57913802542
Lrlc9 nrlc9_1 nrlc9_2 1.40857009536e-08
Crlc9 nrlc9_2 rlc2 5.02807495052e-13
* RLC[12] P1A-rlc5
Rrlc12 P1A nrlc12_1 960988.83432
Lrlc12 nrlc12_1 nrlc12_2 0.972775511795
Crlc12 nrlc12_2 rlc5 4.46876128203e-12
* RLC[13] P1A-rlc6
Rrlc13 P1A nrlc13_1 9044.5398124
Lrlc13 nrlc13_1 nrlc13_2 4.85424402431e-05
Crlc13 nrlc13_2 rlc6 7.82066069792e-16
* RLC[16] P1A-rlc9
Rrlc16 P1A nrlc16_1 0.769041373232
Lrlc16 nrlc16_1 nrlc16_2 3.08444987021e-12
Crlc16 nrlc16_2 rlc9 5.79476458525e-15
* RLC[17] P1A-rlc10
Rrlc17 P1A nrlc17_1 21908.267104
Lrlc17 nrlc17_1 nrlc17_2 2.96259333143e-06
Crlc17 nrlc17_2 rlc10 9.31729376873e-14
* RLC[21] P1A-rlc14
Rrlc21 P1A nrlc21_1 1.71622871812
Lrlc21 nrlc21_1 nrlc21_2 1.32200438417e-08
Crlc21 nrlc21_2 rlc14 4.98700790057e-12
* RLC[24] P2A-P3A
Rrlc24 P2A nrlc24_1 959.643819448
Lrlc24 nrlc24_1 nrlc24_2 8.75525635606e-06
Crlc24 nrlc24_2 P3A 1.05634605862e-14
* RLC[25] P2A-P4A
Rrlc25 P2A nrlc25_1 17139402.9695
Lrlc25 nrlc25_1 nrlc25_2 0.336365626965
Crlc25 nrlc25_2 P4A 1.00806707871e-15
* RLC[26] P2A-P1B
Rrlc26 P2A nrlc26_1 177.73472821
Lrlc26 nrlc26_1 nrlc26_2 7.29534050717e-07
Crlc26 nrlc26_2 P1B 6.12000372088e-14
* RLC[28] P2A-P3B
Rrlc28 P2A nrlc28_1 18858.1946237
Lrlc28 nrlc28_1 nrlc28_2 0.000551811297504
Crlc28 nrlc28_2 P3B 1.72404203844e-15
* RLC[29] P2A-P4B
Rrlc29 P2A nrlc29_1 53368.6256182
Lrlc29 nrlc29_1 nrlc29_2 1.10816345777e-05
Crlc29 nrlc29_2 P4B 2.17744480414e-14
* RLC[30] P2A-rlc0
Rrlc30 P2A nrlc30_1 424716.546992
Lrlc30 nrlc30_1 nrlc30_2 5.63295519315e-09
Crlc30 nrlc30_2 rlc0 1.0058983273e-14
* RLC[31] P2A-rlc1
Rrlc31 P2A nrlc31_1 12244.7349575
Lrlc31 nrlc31_1 nrlc31_2 5.18199776383e-06
Crlc31 nrlc31_2 rlc1 1.78480810191e-13
* RLC[32] P2A-rlc2
Rrlc32 P2A nrlc32_1 168480.71104
Lrlc32 nrlc32_1 nrlc32_2 0.00350262852014
Crlc32 nrlc32_2 rlc2 1.0383938243e-11
* RLC[33] P2A-rlc3
Rrlc33 P2A nrlc33_1 2.38440522598
Lrlc33 nrlc33_1 nrlc33_2 1.81040146811e-08
Crlc33 nrlc33_2 rlc3 3.53811751658e-12
* RLC[34] P2A-rlc4
Rrlc34 P2A nrlc34_1 160084.9492
Lrlc34 nrlc34_1 nrlc34_2 0.384417220434
Crlc34 nrlc34_2 rlc4 3.59456626362e-05
* RLC[36] P2A-rlc6
Rrlc36 P2A nrlc36_1 46004.2647875
Lrlc36 nrlc36_1 nrlc36_2 8.8106748135e-05
Crlc36 nrlc36_2 rlc6 2.78258803332e-13
* RLC[37] P2A-rlc7
Rrlc37 P2A nrlc37_1 1.02793961947
Lrlc37 nrlc37_1 nrlc37_2 1.51990105674e-09
Crlc37 nrlc37_2 rlc7 1.59822381243e-12
* RLC[39] P2A-rlc9
Rrlc39 P2A nrlc39_1 4.34078119202
Lrlc39 nrlc39_1 nrlc39_2 3.18240867019e-08
Crlc39 nrlc39_2 rlc9 1.87662565923e-12
* RLC[40] P2A-rlc10
Rrlc40 P2A nrlc40_1 3075.58725736
Lrlc40 nrlc40_1 nrlc40_2 0.000100303633093
Crlc40 nrlc40_2 rlc10 1.17819744179e-14
* RLC[41] P2A-rlc11
Rrlc41 P2A nrlc41_1 572.421742725
Lrlc41 nrlc41_1 nrlc41_2 4.53100281627e-06
Crlc41 nrlc41_2 rlc11 1.53645406083e-14
* RLC[42] P2A-rlc12
Rrlc42 P2A nrlc42_1 5293657.67512
Lrlc42 nrlc42_1 nrlc42_2 0.874910713272
Crlc42 nrlc42_2 rlc12 4.77215743786e-13
* RLC[44] P2A-rlc14
Rrlc44 P2A nrlc44_1 10111478.8333
Lrlc44 nrlc44_1 nrlc44_2 8.58798943332e-08
Crlc44 nrlc44_2 rlc14 2.09927100886e-14
* RLC[45] P2A-rlc15
Rrlc45 P2A nrlc45_1 466.357684928
Lrlc45 nrlc45_1 nrlc45_2 4.75862844592e-06
Crlc45 nrlc45_2 rlc15 3.68923734774e-14
* RLC[47] P3A-P4A
Rrlc47 P3A nrlc47_1 5.21634466604
Lrlc47 nrlc47_1 nrlc47_2 3.96265769729e-08
Crlc47 nrlc47_2 P4A 1.61812284928e-12
* RLC[49] P3A-P2B
Rrlc49 P3A nrlc49_1 1258270.60958
Lrlc49 nrlc49_1 nrlc49_2 7.47869350176e-08
Crlc49 nrlc49_2 P2B 8.03303376335e-13
* RLC[50] P3A-P3B
Rrlc50 P3A nrlc50_1 24673.2063327
Lrlc50 nrlc50_1 nrlc50_2 0.000623219044955
Crlc50 nrlc50_2 P3B 6.57268998647e-15
* RLC[51] P3A-P4B
Rrlc51 P3A nrlc51_1 2.26915272807
Lrlc51 nrlc51_1 nrlc51_2 3.61228103271e-08
Crlc51 nrlc51_2 P4B 7.79491827309e-12
* RLC[53] P3A-rlc1
Rrlc53 P3A nrlc53_1 504537.047542
Lrlc53 nrlc53_1 nrlc53_2 0.00760163791006
Crlc53 nrlc53_2 rlc1 1.60096428151e-11
* RLC[54] P3A-rlc2
Rrlc54 P3A nrlc54_1 26302.3094116
Lrlc54 nrlc54_1 nrlc54_2 0.000373658588907
Crlc54 nrlc54_2 rlc2 6.00129112727e-16
* RLC[57] P3A-rlc5
Rrlc57 P3A nrlc57_1 633.514024747
Lrlc57 nrlc57_1 nrlc57_2 1.82765289009e-06
Crlc57 nrlc57_2 rlc5 5.05986279592e-15
* RLC[58] P3A-rlc6
Rrlc58 P3A nrlc58_1 2.57969353272
Lrlc58 nrlc58_1 nrlc58_2 6.46659276799e-09
Crlc58 nrlc58_2 rlc6 1.07968426713e-12
* RLC[59] P3A-rlc7
Rrlc59 P3A nrlc59_1 81485.9855051
Lrlc59 nrlc59_1 nrlc59_2 0.000655709322877
Crlc59 nrlc59_2 rlc7 1.83346132086e-13
* RLC[60] P3A-rlc8
Rrlc60 P3A nrlc60_1 1752232.11991
Lrlc60 nrlc60_1 nrlc60_2 0.217153429114
Crlc60 nrlc60_2 rlc8 1.94413359194e-10
* RLC[61] P3A-rlc9
Rrlc61 P3A nrlc61_1 126219.55482
Lrlc61 nrlc61_1 nrlc61_2 0.948322056362
Crlc61 nrlc61_2 rlc9 2.20990736889e-06
* RLC[65] P3A-rlc13
Rrlc65 P3A nrlc65_1 13295.3600904
Lrlc65 nrlc65_1 nrlc65_2 0.000458322191868
Crlc65 nrlc65_2 rlc13 2.88089989876e-15
* RLC[66] P3A-rlc14
Rrlc66 P3A nrlc66_1 10857.2649438
Lrlc66 nrlc66_1 nrlc66_2 0.000121199751074
Crlc66 nrlc66_2 rlc14 1.14240040083e-15
* RLC[69] P4A-P1B
Rrlc69 P4A nrlc69_1 9.05288539185
Lrlc69 nrlc69_1 nrlc69_2 3.29499296047e-08
Crlc69 nrlc69_2 P1B 4.46722613128e-13
* RLC[70] P4A-P2B
Rrlc70 P4A nrlc70_1 8908.72396483
Lrlc70 nrlc70_1 nrlc70_2 3.55341868951e-05
Crlc70 nrlc70_2 P2B 6.98951044847e-15
* RLC[71] P4A-P3B
Rrlc71 P4A nrlc71_1 2.1722409994
Lrlc71 nrlc71_1 nrlc71_2 5.90462220839e-09
Crlc71 nrlc71_2 P3B 1.39038026051e-12
* RLC[72] P4A-P4B
Rrlc72 P4A nrlc72_1 6696.38274897
Lrlc72 nrlc72_1 nrlc72_2 3.43718719056e-05
Crlc72 nrlc72_2 P4B 8.51687233494e-16
* RLC[73] P4A-rlc0
Rrlc73 P4A nrlc73_1 129.314628996
Lrlc73 nrlc73_1 nrlc73_2 1.63549942198e-06
Crlc73 nrlc73_2 rlc0 1.08670726185e-13
* RLC[74] P4A-rlc1
Rrlc74 P4A nrlc74_1 30.1125166466
Lrlc74 nrlc74_1 nrlc74_2 4.16003538061e-07
Crlc74 nrlc74_2 rlc1 5.09753725704e-13
* RLC[75] P4A-rlc2
Rrlc75 P4A nrlc75_1 150332.161918
Lrlc75 nrlc75_1 nrlc75_2 1.83268380467e-09
Crlc75 nrlc75_2 rlc2 3.48661959026e-12
* RLC[76] P4A-rlc3
Rrlc76 P4A nrlc76_1 1865.32225224
Lrlc76 nrlc76_1 nrlc76_2 2.22501794128e-05
Crlc76 nrlc76_2 rlc3 7.10531384212e-15
* RLC[77] P4A-rlc4
Rrlc77 P4A nrlc77_1 2.98406682236
Lrlc77 nrlc77_1 nrlc77_2 3.9761562183e-08
Crlc77 nrlc77_2 rlc4 4.96139541931e-12
* RLC[78] P4A-rlc5
Rrlc78 P4A nrlc78_1 2.12595559006
Lrlc78 nrlc78_1 nrlc78_2 8.97134713904e-09
Crlc78 nrlc78_2 rlc5 2.20549854688e-12
* RLC[82] P4A-rlc9
Rrlc82 P4A nrlc82_1 19.5284415281
Lrlc82 nrlc82_1 nrlc82_2 2.58162983455e-07
Crlc82 nrlc82_2 rlc9 7.52170489686e-13
* RLC[83] P4A-rlc10
Rrlc83 P4A nrlc83_1 157430.516134
Lrlc83 nrlc83_1 nrlc83_2 0.0831453581158
Crlc83 nrlc83_2 rlc10 6.60597237271e-11
* RLC[85] P4A-rlc12
Rrlc85 P4A nrlc85_1 22.6053341658
Lrlc85 nrlc85_1 nrlc85_2 3.03780345935e-07
Crlc85 nrlc85_2 rlc12 6.60534186865e-13
* RLC[87] P4A-rlc14
Rrlc87 P4A nrlc87_1 5443.13723265
Lrlc87 nrlc87_1 nrlc87_2 7.50342378566e-07
Crlc87 nrlc87_2 rlc14 9.19884367146e-16
* RLC[89] P4A-P1B
Rrlc89 P4A nrlc89_1 367.332575237
Lrlc89 nrlc89_1 nrlc89_2 4.49588649513e-06
Crlc89 nrlc89_2 P1B 3.70214941012e-14
* RLC[90] P1B-P2B
Rrlc90 P1B nrlc90_1 5.40794771415
Lrlc90 nrlc90_1 nrlc90_2 2.85871280325e-06
Crlc90 nrlc90_2 P2B 2.59084751563e-07
* RLC[91] P1B-P3B
Rrlc91 P1B nrlc91_1 3.2848441196
Lrlc91 nrlc91_1 nrlc91_2 8.14720150669e-08
Crlc91 nrlc91_2 P3B 8.38950656317e-12
* RLC[92] P1B-P4B
Rrlc92 P1B nrlc92_1 205.422197217
Lrlc92 nrlc92_1 nrlc92_2 5.5605200774e-07
Crlc92 nrlc92_2 P4B 1.46412502404e-14
* RLC[93] P1B-rlc0
Rrlc93 P1B nrlc93_1 4.44838676249
Lrlc93 nrlc93_1 nrlc93_2 1.02383875096e-08
Crlc93 nrlc93_2 rlc0 2.09460413006e-07
* RLC[94] P1B-rlc1
Rrlc94 P1B nrlc94_1 0.178604462203
Lrlc94 nrlc94_1 nrlc94_2 6.74482262039e-09
Crlc94 nrlc94_2 rlc1 0.001
* RLC[96] P1B-rlc3
Rrlc96 P1B nrlc96_1 0.0352397180099
Lrlc96 nrlc96_1 nrlc96_2 7.73577174134e-10
Crlc96 nrlc96_2 rlc3 6.92143728514e-10
* RLC[97] P1B-rlc4
Rrlc97 P1B nrlc97_1 84.6804865377
Lrlc97 nrlc97_1 nrlc97_2 1.92674480003e-06
Crlc97 nrlc97_2 rlc4 2.98548571073e-13
* RLC[98] P1B-rlc5
Rrlc98 P1B nrlc98_1 2720.35902281
Lrlc98 nrlc98_1 nrlc98_2 0.00171396680193
Crlc98 nrlc98_2 rlc5 2.14090214512e-10
* RLC[100] P1B-rlc7
Rrlc100 P1B nrlc100_1 6.5922696256
Lrlc100 nrlc100_1 nrlc100_2 6.99032572708e-08
Crlc100 nrlc100_2 rlc7 3.14700039044e-11
* RLC[102] P1B-rlc9
Rrlc102 P1B nrlc102_1 2.0661428383
Lrlc102 nrlc102_1 nrlc102_2 5.74785353754e-09
Crlc102 nrlc102_2 rlc9 0.000999778147547
* RLC[105] P1B-rlc12
Rrlc105 P1B nrlc105_1 0.574875448726
Lrlc105 nrlc105_1 nrlc105_2 1.99454832474e-06
Crlc105 nrlc105_2 rlc12 2.77822881193e-08
* RLC[106] P1B-rlc13
Rrlc106 P1B nrlc106_1 35.4609061954
Lrlc106 nrlc106_1 nrlc106_2 1.35056475138e-06
Crlc106 nrlc106_2 rlc13 1.92776112823e-12
* RLC[111] P2B-P4B
Rrlc111 P2B nrlc111_1 68.344199979
Lrlc111 nrlc111_1 nrlc111_2 1.83358975931e-05
Crlc111 nrlc111_2 P4B 1.37608407907e-08
* RLC[114] P2B-rlc2
Rrlc114 P2B nrlc114_1 0.866655486133
Lrlc114 nrlc114_1 nrlc114_2 2.15700268836e-09
Crlc114 nrlc114_2 rlc2 3.19091470823e-12
* RLC[115] P2B-rlc3
Rrlc115 P2B nrlc115_1 8.5221533606
Lrlc115 nrlc115_1 nrlc115_2 0.000304641814344
Crlc115 nrlc115_2 rlc3 5.34037152606e-06
* RLC[117] P2B-rlc5
Rrlc117 P2B nrlc117_1 1549.93207332
Lrlc117 nrlc117_1 nrlc117_2 0.00129094368212
Crlc117 nrlc117_2 rlc5 5.93511458012e-10
* RLC[122] P2B-rlc10
Rrlc122 P2B nrlc122_1 340.503017577
Lrlc122 nrlc122_1 nrlc122_2 1.98008670907e-06
Crlc122 nrlc122_2 rlc10 1.04508047107e-07
* RLC[123] P2B-rlc11
Rrlc123 P2B nrlc123_1 2247.11790663
Lrlc123 nrlc123_1 nrlc123_2 1.32904794552e-05
Crlc123 nrlc123_2 rlc11 2.92446493178e-15
* RLC[125] P2B-rlc13
Rrlc125 P2B nrlc125_1 34.0769429544
Lrlc125 nrlc125_1 nrlc125_2 0.00177861258028
Crlc125 nrlc125_2 rlc13 1.70183556717e-09
* RLC[126] P2B-rlc14
Rrlc126 P2B nrlc126_1 0.264513761621
Lrlc126 nrlc126_1 nrlc126_2 1.62049351046e-08
Crlc126 nrlc126_2 rlc14 2.57340561076e-10
* RLC[127] P2B-rlc15
Rrlc127 P2B nrlc127_1 1012.84936692
Lrlc127 nrlc127_1 nrlc127_2 0.000104081767182
Crlc127 nrlc127_2 rlc15 3.45880065495e-10
* RLC[130] P3B-rlc0
Rrlc130 P3B nrlc130_1 0.01
Lrlc130 nrlc130_1 nrlc130_2 1.39836953484e-10
Crlc130 nrlc130_2 rlc0 4.78297622445e-07
* RLC[131] P3B-rlc1
Rrlc131 P3B nrlc131_1 0.01
Lrlc131 nrlc131_1 nrlc131_2 4.04220701988e-12
Crlc131 nrlc131_2 rlc1 3.47887732124e-10
* RLC[132] P3B-rlc2
Rrlc132 P3B nrlc132_1 107.841729804
Lrlc132 nrlc132_1 nrlc132_2 1.96038862844e-06
Crlc132 nrlc132_2 rlc2 1.87294909734e-13
* RLC[135] P3B-rlc5
Rrlc135 P3B nrlc135_1 5.45242992298
Lrlc135 nrlc135_1 nrlc135_2 9.78476218066e-08
Crlc135 nrlc135_2 rlc5 3.65702205939e-12
* RLC[136] P3B-rlc6
Rrlc136 P3B nrlc136_1 327.875891478
Lrlc136 nrlc136_1 nrlc136_2 6.72621853738e-07
Crlc136 nrlc136_2 rlc6 5.01973032812e-12
* RLC[137] P3B-rlc7
Rrlc137 P3B nrlc137_1 361.369120198
Lrlc137 nrlc137_1 nrlc137_2 1.35244295718e-06
Crlc137 nrlc137_2 rlc7 6.40471415919e-11
* RLC[139] P3B-rlc9
Rrlc139 P3B nrlc139_1 7.97033517842
Lrlc139 nrlc139_1 nrlc139_2 4.24639329841e-08
Crlc139 nrlc139_2 rlc9 1.28781367193e-12
* RLC[140] P3B-rlc10
Rrlc140 P3B nrlc140_1 0.923889927582
Lrlc140 nrlc140_1 nrlc140_2 2.02409493147e-08
Crlc140 nrlc140_2 rlc10 2.63480150699e-11
* RLC[141] P3B-rlc11
Rrlc141 P3B nrlc141_1 1.2824214343
Lrlc141 nrlc141_1 nrlc141_2 3.07984120588e-08
Crlc141 nrlc141_2 rlc11 2.08077096651e-11
* RLC[143] P3B-rlc13
Rrlc143 P3B nrlc143_1 65.4601448552
Lrlc143 nrlc143_1 nrlc143_2 6.43424384503e-07
Crlc143 nrlc143_2 rlc13 1.66840346183e-13
* RLC[146] P3B-P1B
Rrlc146 P3B nrlc146_1 0.80777579318
Lrlc146 nrlc146_1 nrlc146_2 5.1194829739e-08
Crlc146 nrlc146_2 P1B 9.63974879822e-07
* RLC[147] P4B-rlc0
Rrlc147 P4B nrlc147_1 228.252891896
Lrlc147 nrlc147_1 nrlc147_2 1.66603814169e-06
Crlc147 nrlc147_2 rlc0 3.55311981888e-14
* RLC[148] P4B-rlc1
Rrlc148 P4B nrlc148_1 14.5716414518
Lrlc148 nrlc148_1 nrlc148_2 1.06519727877e-07
Crlc148 nrlc148_2 rlc1 5.57404648035e-13
* RLC[150] P4B-rlc3
Rrlc150 P4B nrlc150_1 5.60293282496
Lrlc150 nrlc150_1 nrlc150_2 4.02284225283e-08
Crlc150 nrlc150_2 rlc3 1.42383499324e-12
* RLC[152] P4B-rlc5
Rrlc152 P4B nrlc152_1 5.96610778212
Lrlc152 nrlc152_1 nrlc152_2 2.02549618321e-08
Crlc152 nrlc152_2 rlc5 6.32276047587e-13
* RLC[153] P4B-rlc6
Rrlc153 P4B nrlc153_1 9.86553227523
Lrlc153 nrlc153_1 nrlc153_2 2.55346080897e-08
Crlc153 nrlc153_2 rlc6 2.9150475527e-13
* RLC[156] P4B-rlc9
Rrlc156 P4B nrlc156_1 1456.85324936
Lrlc156 nrlc156_1 nrlc156_2 1.06358545573e-05
Crlc156 nrlc156_2 rlc9 5.56798769066e-15
* RLC[158] P4B-rlc11
Rrlc158 P4B nrlc158_1 17.2225338633
Lrlc158 nrlc158_1 nrlc158_2 1.20368201224e-07
Crlc158 nrlc158_2 rlc11 4.50894737288e-13
* RLC[159] P4B-rlc12
Rrlc159 P4B nrlc159_1 15.3534099401
Lrlc159 nrlc159_1 nrlc159_2 4.12208377329e-08
Crlc159 nrlc159_2 rlc12 1.94296336774e-13
* RLC[160] P4B-rlc13
Rrlc160 P4B nrlc160_1 5473.18113916
Lrlc160 nrlc160_1 nrlc160_2 3.49009194397e-05
Crlc160 nrlc160_2 rlc13 1.29453773823e-15
* RLC[162] P4B-rlc15
Rrlc162 P4B nrlc162_1 1565.77400896
Lrlc162 nrlc162_1 nrlc162_2 4.28479812756e-05
Crlc162 nrlc162_2 rlc15 4.8946021093e-08
* RLC[163] P4B-P1B
Rrlc163 P4B nrlc163_1 751.749147307
Lrlc163 nrlc163_1 nrlc163_2 1.65559320608e-14
Crlc163 nrlc163_2 P1B 1.34974340555e-14
* RLC[167] rlc0-rlc4
Rrlc167 rlc0 nrlc167_1 9.90277453233
Lrlc167 nrlc167_1 nrlc167_2 3.75981702886e-08
Crlc167 nrlc167_2 rlc4 7.9946152046e-11
* RLC[168] rlc0-rlc5
Rrlc168 rlc0 nrlc168_1 389.763359334
Lrlc168 nrlc168_1 nrlc168_2 3.98221047448e-06
Crlc168 nrlc168_2 rlc5 2.91259219492e-14
* RLC[169] rlc0-rlc6
Rrlc169 rlc0 nrlc169_1 4.94240711107
Lrlc169 nrlc169_1 nrlc169_2 6.50698630798e-08
Crlc169 nrlc169_2 rlc6 2.95978627407e-12
* RLC[170] rlc0-rlc7
Rrlc170 rlc0 nrlc170_1 29.0261007247
Lrlc170 nrlc170_1 nrlc170_2 4.44361139909e-07
Crlc170 nrlc170_2 rlc7 5.86025031328e-13
* RLC[172] rlc0-rlc9
Rrlc172 rlc0 nrlc172_1 29.2587514312
Lrlc172 nrlc172_1 nrlc172_2 8.47026288956e-08
Crlc172 nrlc172_2 rlc9 3.29328201139e-11
* RLC[173] rlc0-rlc10
Rrlc173 rlc0 nrlc173_1 45.7370958278
Lrlc173 nrlc173_1 nrlc173_2 1.92886546865e-07
Crlc173 nrlc173_2 rlc10 4.87295361577e-10
* RLC[174] rlc0-rlc11
Rrlc174 rlc0 nrlc174_1 16.3538507129
Lrlc174 nrlc174_1 nrlc174_2 3.80610706597e-07
Crlc174 nrlc174_2 rlc11 1.58124233573e-12
* RLC[176] rlc0-rlc13
Rrlc176 rlc0 nrlc176_1 12.4659177023
Lrlc176 nrlc176_1 nrlc176_2 2.69468987419e-07
Crlc176 nrlc176_2 rlc13 1.92671629377e-12
* RLC[177] rlc0-rlc14
Rrlc177 rlc0 nrlc177_1 17051.2529774
Lrlc177 nrlc177_1 nrlc177_2 0.00365424988192
Crlc177 nrlc177_2 rlc14 1.02851328981e-05
* RLC[178] rlc0-rlc15
Rrlc178 rlc0 nrlc178_1 0.408523116067
Lrlc178 nrlc178_1 nrlc178_2 5.76643146687e-09
Crlc178 nrlc178_2 rlc15 3.83911705199e-11
* RLC[179] rlc0-P1B
Rrlc179 rlc0 nrlc179_1 1.33477502867
Lrlc179 nrlc179_1 nrlc179_2 7.30815159972e-10
Crlc179 nrlc179_2 P1B 8.37066882632e-12
* RLC[180] rlc1-rlc2
Rrlc180 rlc1 nrlc180_1 6819.50946674
Lrlc180 nrlc180_1 nrlc180_2 2.62905260472e-05
Crlc180 nrlc180_2 rlc2 1.10612633412e-06
* RLC[181] rlc1-rlc3
Rrlc181 rlc1 nrlc181_1 14.0416414005
Lrlc181 nrlc181_1 nrlc181_2 1.31881462365e-07
Crlc181 nrlc181_2 rlc3 1.74012884157e-11
* RLC[182] rlc1-rlc4
Rrlc182 rlc1 nrlc182_1 0.10835292409
Lrlc182 nrlc182_1 nrlc182_2 3.02998660472e-09
Crlc182 nrlc182_2 rlc4 2.86758914081e-10
* RLC[183] rlc1-rlc5
Rrlc183 rlc1 nrlc183_1 56.7105131156
Lrlc183 nrlc183_1 nrlc183_2 8.71697178194e-07
Crlc183 nrlc183_2 rlc5 3.01159090633e-13
* RLC[184] rlc1-rlc6
Rrlc184 rlc1 nrlc184_1 149.384042409
Lrlc184 nrlc184_1 nrlc184_2 2.42782419371e-06
Crlc184 nrlc184_2 rlc6 7.41616809059e-13
* RLC[185] rlc1-rlc7
Rrlc185 rlc1 nrlc185_1 83.6046735791
Lrlc185 nrlc185_1 nrlc185_2 2.98303175096e-07
Crlc185 nrlc185_2 rlc7 4.17506795993e-13
* RLC[186] rlc1-rlc8
Rrlc186 rlc1 nrlc186_1 56.8618264667
Lrlc186 nrlc186_1 nrlc186_2 3.15603493933e-07
Crlc186 nrlc186_2 rlc8 5.16596004248e-05
* RLC[191] rlc1-rlc13
Rrlc191 rlc1 nrlc191_1 237.517488246
Lrlc191 nrlc191_1 nrlc191_2 1.61546715065e-07
Crlc191 nrlc191_2 rlc13 8.91568110627e-09
* RLC[194] rlc1-P1B
Rrlc194 rlc1 nrlc194_1 0.670818056433
Lrlc194 nrlc194_1 nrlc194_2 7.23030236194e-09
Crlc194 nrlc194_2 P1B 2.14619744606e-08
* RLC[195] rlc2-rlc3
Rrlc195 rlc2 nrlc195_1 0.0177307408145
Lrlc195 nrlc195_1 nrlc195_2 1.95666638375e-11
Crlc195 nrlc195_2 rlc3 6.91545104876e-11
* RLC[197] rlc2-rlc5
Rrlc197 rlc2 nrlc197_1 107.897243439
Lrlc197 nrlc197_1 nrlc197_2 1.83137778461e-06
Crlc197 nrlc197_2 rlc5 0.001
* RLC[198] rlc2-rlc6
Rrlc198 rlc2 nrlc198_1 1.52274007126
Lrlc198 nrlc198_1 nrlc198_2 2.18847933388e-08
Crlc198 nrlc198_2 rlc6 1.04869654586e-11
* RLC[199] rlc2-rlc7
Rrlc199 rlc2 nrlc199_1 3390.32046249
Lrlc199 nrlc199_1 nrlc199_2 0.000934494606508
Crlc199 nrlc199_2 rlc7 1.4412660666e-10
* RLC[200] rlc2-rlc8
Rrlc200 rlc2 nrlc200_1 93.2726799109
Lrlc200 nrlc200_1 nrlc200_2 2.60209200182e-12
Crlc200 nrlc200_2 rlc8 1.37181036639e-13
* RLC[201] rlc2-rlc9
Rrlc201 rlc2 nrlc201_1 29.7078862416
Lrlc201 nrlc201_1 nrlc201_2 5.96886004931e-07
Crlc201 nrlc201_2 rlc9 7.51459159287e-13
* RLC[202] rlc2-rlc10
Rrlc202 rlc2 nrlc202_1 655.357998979
Lrlc202 nrlc202_1 nrlc202_2 2.840587997e-06
Crlc202 nrlc202_2 rlc10 2.95760810193e-11
* RLC[203] rlc2-rlc11
Rrlc203 rlc2 nrlc203_1 0.29435483685
Lrlc203 nrlc203_1 nrlc203_2 1.24076960724e-09
Crlc203 nrlc203_2 rlc11 1.5911322718e-11
* RLC[204] rlc2-rlc12
Rrlc204 rlc2 nrlc204_1 18.5787148865
Lrlc204 nrlc204_1 nrlc204_2 1.48479676689e-07
Crlc204 nrlc204_2 rlc12 3.65067031355e-12
* RLC[205] rlc2-rlc13
Rrlc205 rlc2 nrlc205_1 92.5369825792
Lrlc205 nrlc205_1 nrlc205_2 3.84128032525e-06
Crlc205 nrlc205_2 rlc13 4.98428450803e-13
* RLC[206] rlc2-rlc14
Rrlc206 rlc2 nrlc206_1 3195.07247574
Lrlc206 nrlc206_1 nrlc206_2 3.55745341409e-05
Crlc206 nrlc206_2 rlc14 1.43618699761e-10
* RLC[207] rlc2-rlc15
Rrlc207 rlc2 nrlc207_1 23.6983485555
Lrlc207 nrlc207_1 nrlc207_2 2.3430760477e-07
Crlc207 nrlc207_2 rlc15 4.63561873502e-13
* RLC[208] rlc2-P1B
Rrlc208 rlc2 nrlc208_1 18.2629791078
Lrlc208 nrlc208_1 nrlc208_2 1.87494050186e-07
Crlc208 nrlc208_2 P1B 5.22272264475e-12
* RLC[209] rlc3-rlc4
Rrlc209 rlc3 nrlc209_1 2.83515620028
Lrlc209 nrlc209_1 nrlc209_2 8.30297560512e-09
Crlc209 nrlc209_2 rlc4 1.14772900295e-12
* RLC[210] rlc3-rlc5
Rrlc210 rlc3 nrlc210_1 151.000353042
Lrlc210 nrlc210_1 nrlc210_2 1.5507896044e-06
Crlc210 nrlc210_2 rlc5 7.84511066027e-11
* RLC[211] rlc3-rlc6
Rrlc211 rlc3 nrlc211_1 689.994138211
Lrlc211 nrlc211_1 nrlc211_2 1.70866788516e-06
Crlc211 nrlc211_2 rlc6 2.28156153636e-14
* RLC[213] rlc3-rlc8
Rrlc213 rlc3 nrlc213_1 21.7998362687
Lrlc213 nrlc213_1 nrlc213_2 8.73605261876e-07
Crlc213 nrlc213_2 rlc8 2.04251976695e-12
* RLC[214] rlc3-rlc9
Rrlc214 rlc3 nrlc214_1 0.149658127501
Lrlc214 nrlc214_1 nrlc214_2 4.73942560133e-09
Crlc214 nrlc214_2 rlc9 2.35116217643e-10
* RLC[216] rlc3-rlc11
Rrlc216 rlc3 nrlc216_1 28.8204090882
Lrlc216 nrlc216_1 nrlc216_2 1.07851152242e-07
Crlc216 nrlc216_2 rlc11 2.02646127862e-11
* RLC[220] rlc3-rlc15
Rrlc220 rlc3 nrlc220_1 1.71277605327
Lrlc220 nrlc220_1 nrlc220_2 2.16709123523e-08
Crlc220 nrlc220_2 rlc15 8.20793052171e-12
* RLC[221] rlc3-P1B
Rrlc221 rlc3 nrlc221_1 138.14623209
Lrlc221 nrlc221_1 nrlc221_2 1.82080125153e-11
Crlc221 nrlc221_2 P1B 4.56659250871e-09
* RLC[223] rlc4-rlc6
Rrlc223 rlc4 nrlc223_1 118.384538957
Lrlc223 nrlc223_1 nrlc223_2 1.17766439724e-06
Crlc223 nrlc223_2 rlc6 1.75959015731e-12
* RLC[224] rlc4-rlc7
Rrlc224 rlc4 nrlc224_1 57.4609837185
Lrlc224 nrlc224_1 nrlc224_2 6.27980357449e-07
Crlc224 nrlc224_2 rlc7 2.11328191652e-13
* RLC[225] rlc4-rlc8
Rrlc225 rlc4 nrlc225_1 0.255451689337
Lrlc225 nrlc225_1 nrlc225_2 5.89311283438e-09
Crlc225 nrlc225_2 rlc8 1.00342447278e-10
* RLC[226] rlc4-rlc9
Rrlc226 rlc4 nrlc226_1 0.493428933683
Lrlc226 nrlc226_1 nrlc226_2 2.92036951866e-09
Crlc226 nrlc226_2 rlc9 1.33274196627e-11
* RLC[227] rlc4-rlc10
Rrlc227 rlc4 nrlc227_1 415.332570216
Lrlc227 nrlc227_1 nrlc227_2 1.20941147753e-05
Crlc227 nrlc227_2 rlc10 2.67718712483e-05
* RLC[228] rlc4-rlc11
Rrlc228 rlc4 nrlc228_1 35.3381564519
Lrlc228 nrlc228_1 nrlc228_2 9.51201866466e-08
Crlc228 nrlc228_2 rlc11 0.001
* RLC[229] rlc4-rlc12
Rrlc229 rlc4 nrlc229_1 0.0100000050886
Lrlc229 nrlc229_1 nrlc229_2 1.98222008106e-12
Crlc229 nrlc229_2 rlc12 2.51590564328e-10
* RLC[230] rlc4-rlc13
Rrlc230 rlc4 nrlc230_1 3.35160976761
Lrlc230 nrlc230_1 nrlc230_2 1.9182778963e-08
Crlc230 nrlc230_2 rlc13 1.89741407704e-12
* RLC[234] rlc5-rlc6
Rrlc234 rlc5 nrlc234_1 0.0952656699859
Lrlc234 nrlc234_1 nrlc234_2 1.68978814419e-07
Crlc234 nrlc234_2 rlc6 1.94990965102e-07
* RLC[235] rlc5-rlc7
Rrlc235 rlc5 nrlc235_1 0.0390780603498
Lrlc235 nrlc235_1 nrlc235_2 0.00137438532063
Crlc235 nrlc235_2 rlc7 0.001
* RLC[237] rlc5-rlc9
Rrlc237 rlc5 nrlc237_1 0.145031209598
Lrlc237 nrlc237_1 nrlc237_2 8.33566701343e-13
Crlc237 nrlc237_2 rlc9 4.4032658776e-14
* RLC[238] rlc5-rlc10
Rrlc238 rlc5 nrlc238_1 23877.4601759
Lrlc238 nrlc238_1 nrlc238_2 0.00665995503816
Crlc238 nrlc238_2 rlc10 8.64214954179e-12
* RLC[239] rlc5-rlc11
Rrlc239 rlc5 nrlc239_1 387.181996727
Lrlc239 nrlc239_1 nrlc239_2 2.4827790627e-06
Crlc239 nrlc239_2 rlc11 1.84020132213e-14
* RLC[240] rlc5-rlc12
Rrlc240 rlc5 nrlc240_1 1091.25101104
Lrlc240 nrlc240_1 nrlc240_2 1.4919754413e-05
Crlc240 nrlc240_2 rlc12 1.39209811968e-14
* RLC[242] rlc5-rlc14
Rrlc242 rlc5 nrlc242_1 3711.21371765
Lrlc242 nrlc242_1 nrlc242_2 1.58274352335e-05
Crlc242 nrlc242_2 rlc14 5.12254823996e-13
* RLC[243] rlc5-rlc15
Rrlc243 rlc5 nrlc243_1 0.0140207225938
Lrlc243 nrlc243_1 nrlc243_2 4.42461536328e-13
Crlc243 nrlc243_2 rlc15 2.50087635336e-12
* RLC[244] rlc5-P1B
Rrlc244 rlc5 nrlc244_1 573.845614755
Lrlc244 nrlc244_1 nrlc244_2 2.52732307377e-05
Crlc244 nrlc244_2 P1B 1.27317889356e-09
* RLC[245] rlc6-rlc7
Rrlc245 rlc6 nrlc245_1 23.3836468705
Lrlc245 nrlc245_1 nrlc245_2 2.49901058995e-07
Crlc245 nrlc245_2 rlc7 5.07809825085e-13
* RLC[246] rlc6-rlc8
Rrlc246 rlc6 nrlc246_1 17.151231882
Lrlc246 nrlc246_1 nrlc246_2 1.16902659297e-07
Crlc246 nrlc246_2 rlc8 7.85647000188e-13
* RLC[247] rlc6-rlc9
Rrlc247 rlc6 nrlc247_1 0.404298720804
Lrlc247 nrlc247_1 nrlc247_2 0.00790597825805
Crlc247 nrlc247_2 rlc9 0.000106795624874
* RLC[248] rlc6-rlc10
Rrlc248 rlc6 nrlc248_1 0.283616278352
Lrlc248 nrlc248_1 nrlc248_2 3.75454219083e-10
Crlc248 nrlc248_2 rlc10 5.18623476215e-12
* RLC[249] rlc6-rlc11
Rrlc249 rlc6 nrlc249_1 250.853883274
Lrlc249 nrlc249_1 nrlc249_2 4.9288741052e-07
Crlc249 nrlc249_2 rlc11 3.43258687445e-11
* RLC[250] rlc6-rlc12
Rrlc250 rlc6 nrlc250_1 15.0015840896
Lrlc250 nrlc250_1 nrlc250_2 2.41131384123e-07
Crlc250 nrlc250_2 rlc12 1.19052080178e-12
* RLC[251] rlc6-rlc13
Rrlc251 rlc6 nrlc251_1 764.089296271
Lrlc251 nrlc251_1 nrlc251_2 0.00160047339297
Crlc251 nrlc251_2 rlc13 1.27005803629e-09
* RLC[252] rlc6-rlc14
Rrlc252 rlc6 nrlc252_1 9283.70722986
Lrlc252 nrlc252_1 nrlc252_2 4.4932649651e-06
Crlc252 nrlc252_2 rlc14 4.95097630032e-12
* RLC[253] rlc6-rlc15
Rrlc253 rlc6 nrlc253_1 31.4347810848
Lrlc253 nrlc253_1 nrlc253_2 4.69487167095e-07
Crlc253 nrlc253_2 rlc15 5.27910543562e-13
* RLC[254] rlc6-P1B
Rrlc254 rlc6 nrlc254_1 8995.94091426
Lrlc254 nrlc254_1 nrlc254_2 0.0942384127453
Crlc254 nrlc254_2 P1B 2.17270946866e-11
* RLC[255] rlc7-rlc8
Rrlc255 rlc7 nrlc255_1 0.847783786103
Lrlc255 nrlc255_1 nrlc255_2 9.13910339241e-09
Crlc255 nrlc255_2 rlc8 1.41283312373e-11
* RLC[256] rlc7-rlc9
Rrlc256 rlc7 nrlc256_1 0.0111618201277
Lrlc256 nrlc256_1 nrlc256_2 0.000112127605706
Crlc256 nrlc256_2 rlc9 0.001
* RLC[258] rlc7-rlc11
Rrlc258 rlc7 nrlc258_1 0.795412909947
Lrlc258 nrlc258_1 nrlc258_2 4.6541468495e-09
Crlc258 nrlc258_2 rlc11 8.17357969924e-12
* RLC[262] rlc7-rlc15
Rrlc262 rlc7 nrlc262_1 31.0326107403
Lrlc262 nrlc262_1 nrlc262_2 7.54045751208e-08
Crlc262 nrlc262_2 rlc15 1.51188211871e-11
* RLC[263] rlc7-P1B
Rrlc263 rlc7 nrlc263_1 635.734813588
Lrlc263 nrlc263_1 nrlc263_2 1.86251412599e-05
Crlc263 nrlc263_2 P1B 0.000406535046448
* RLC[267] rlc8-rlc12
Rrlc267 rlc8 nrlc267_1 1.52432827708
Lrlc267 nrlc267_1 nrlc267_2 2.566187143e-09
Crlc267 nrlc267_2 rlc12 1.46601808191e-10
* RLC[268] rlc8-rlc13
Rrlc268 rlc8 nrlc268_1 1.39971574907
Lrlc268 nrlc268_1 nrlc268_2 4.8362757297e-08
Crlc268 nrlc268_2 rlc13 2.74276655771e-11
* RLC[269] rlc8-rlc14
Rrlc269 rlc8 nrlc269_1 1944.4107989
Lrlc269 nrlc269_1 nrlc269_2 8.38781325744e-06
Crlc269 nrlc269_2 rlc14 1.09681573272e-12
* RLC[270] rlc8-rlc15
Rrlc270 rlc8 nrlc270_1 82.849925605
Lrlc270 nrlc270_1 nrlc270_2 5.78858617557e-07
Crlc270 nrlc270_2 rlc15 3.8626946386e-10
* RLC[271] rlc8-P1B
Rrlc271 rlc8 nrlc271_1 73.2565335066
Lrlc271 nrlc271_1 nrlc271_2 1.54601639627e-06
Crlc271 nrlc271_2 P1B 3.20094976154e-13
* RLC[272] rlc9-rlc10
Rrlc272 rlc9 nrlc272_1 36.3558927677
Lrlc272 nrlc272_1 nrlc272_2 8.97893702817e-07
Crlc272 nrlc272_2 rlc10 4.49064136292e-09
* RLC[273] rlc9-rlc11
Rrlc273 rlc9 nrlc273_1 0.0100000017085
Lrlc273 nrlc273_1 nrlc273_2 1.03962838779e-08
Crlc273 nrlc273_2 rlc11 0.001
* RLC[274] rlc9-rlc12
Rrlc274 rlc9 nrlc274_1 2.49816102428
Lrlc274 nrlc274_1 nrlc274_2 3.73260584467e-08
Crlc274 nrlc274_2 rlc12 1.73064792515e-11
* RLC[275] rlc9-rlc13
Rrlc275 rlc9 nrlc275_1 36.7795297587
Lrlc275 nrlc275_1 nrlc275_2 6.16382194741e-07
Crlc275 nrlc275_2 rlc13 5.0628519859e-13
* RLC[276] rlc9-rlc14
Rrlc276 rlc9 nrlc276_1 47203.0662468
Lrlc276 nrlc276_1 nrlc276_2 0.0693911611077
Crlc276 nrlc276_2 rlc14 9.43874110168e-12
* RLC[278] rlc9-P1B
Rrlc278 rlc9 nrlc278_1 0.01
Lrlc278 nrlc278_1 nrlc278_2 1.79219685676e-06
Crlc278 nrlc278_2 P1B 0.001
* RLC[280] rlc10-rlc12
Rrlc280 rlc10 nrlc280_1 0.0694109669324
Lrlc280 nrlc280_1 nrlc280_2 4.95241577812e-08
Crlc280 nrlc280_2 rlc12 1.14213752442e-08
* RLC[281] rlc10-rlc13
Rrlc281 rlc10 nrlc281_1 100.292486469
Lrlc281 nrlc281_1 nrlc281_2 3.65497823283e-06
Crlc281 nrlc281_2 rlc13 4.03743448667e-13
* RLC[283] rlc10-rlc15
Rrlc283 rlc10 nrlc283_1 2932.79829636
Lrlc283 nrlc283_1 nrlc283_2 3.14896686257e-05
Crlc283 nrlc283_2 rlc15 4.06781497101e-15
* RLC[285] rlc11-rlc12
Rrlc285 rlc11 nrlc285_1 12.5186696998
Lrlc285 nrlc285_1 nrlc285_2 2.03570928562e-07
Crlc285 nrlc285_2 rlc12 7.14023306595e-12
* RLC[286] rlc11-rlc13
Rrlc286 rlc11 nrlc286_1 2.40201539387
Lrlc286 nrlc286_1 nrlc286_2 3.11820736746e-08
Crlc286 nrlc286_2 rlc13 6.00497095561e-12
* RLC[288] rlc11-rlc15
Rrlc288 rlc11 nrlc288_1 11.7223475325
Lrlc288 nrlc288_1 nrlc288_2 4.76658971019e-08
Crlc288 nrlc288_2 rlc15 3.17761455078e-12
* RLC[289] rlc11-P1B
Rrlc289 rlc11 nrlc289_1 10.2806659322
Lrlc289 nrlc289_1 nrlc289_2 7.57668849486e-08
Crlc289 nrlc289_2 P1B 1.30702690252e-12
* RLC[292] rlc12-rlc15
Rrlc292 rlc12 nrlc292_1 51.1493759455
Lrlc292 nrlc292_1 nrlc292_2 4.47395952729e-07
Crlc292 nrlc292_2 rlc15 1.90006677022e-13
* RLC[293] rlc12-P1B
Rrlc293 rlc12 nrlc293_1 11.2532010328
Lrlc293 nrlc293_1 nrlc293_2 2.42936958997e-08
Crlc293 nrlc293_2 P1B 7.96614236751e-13
* RLC[294] rlc13-rlc14
Rrlc294 rlc13 nrlc294_1 1181.5533854
Lrlc294 nrlc294_1 nrlc294_2 4.38221282452e-05
Crlc294 nrlc294_2 rlc14 3.48774125373e-14
* RLC[298] rlc14-P1B
Rrlc298 rlc14 nrlc298_1 1.46331057734
Lrlc298 nrlc298_1 nrlc298_2 3.82800863661e-09
Crlc298 nrlc298_2 P1B 1.98635732303e-12
* DC[0] P1A-P2A
Rdc0 P1A ndc0_1 0.100152194059
Ldc0 ndc0_1 P2A 5.45290168977e-08
* DC[23] P3A-P4A
Rdc23 P3A ndc23_1 0.0966100848854
Ldc23 ndc23_1 P4A 6.69382414961e-08
* DC[42] P1B-P2B
Rdc42 P1B ndc42_1 0.108890373452
Ldc42 ndc42_1 P2B 9.31485021754e-08
* DC[43] P1B-P3B
Rdc43 P1B ndc43_1 34.4533702998
Ldc43 ndc43_1 P3B 5.48342418939e-06
* DC[45] P1B-dc0
Rdc45 P1B ndc45_1 0.0265624293698
Ldc45 ndc45_1 dc0 4.28829181856e-09
* DC[46] P1B-dc1
Rdc46 P1B ndc46_1 0.297758850317
Ldc46 ndc46_1 dc1 2.05928227838e-07
* DC[47] P1B-dc2
Rdc47 P1B ndc47_1 0.209709792164
Ldc47 ndc47_1 dc2 2.46369612369e-07
* DC[48] P1B-dc3
Rdc48 P1B ndc48_1 0.0445185073261
Ldc48 ndc48_1 dc3 2.33527949796e-08
* DC[51] P2B-P4B
Rdc51 P2B ndc51_1 2.73256827063
Ldc51 ndc51_1 P4B 1.60910724079e-06
* DC[52] P2B-dc0
Rdc52 P2B ndc52_1 4.61574060726
Ldc52 ndc52_1 dc0 4.14149127932e-06
* DC[53] P2B-dc1
Rdc53 P2B ndc53_1 0.148491555559
Ldc53 ndc53_1 dc1 1.32758336809e-07
* DC[54] P2B-dc2
Rdc54 P2B ndc54_1 0.139302617545
Ldc54 ndc54_1 dc2 1.04383802451e-07
* DC[55] P2B-dc3
Rdc55 P2B ndc55_1 0.173613623139
Ldc55 ndc55_1 dc3 1.55021731151e-07
* DC[56] P2B-P1B
Rdc56 P2B ndc56_1 10.6399089427
Ldc56 ndc56_1 P1B 9.10173803808e-06
* DC[57] P3B-P4B
Rdc57 P3B ndc57_1 0.120526395936
Ldc57 ndc57_1 P4B 6.08481647598e-08
* DC[58] P3B-dc0
Rdc58 P3B ndc58_1 1.23600989912
Ldc58 ndc58_1 dc0 1.30699651636e-06
* DC[59] P3B-dc1
Rdc59 P3B ndc59_1 1.07021399468
Ldc59 ndc59_1 dc1 0.000120544010658
* DC[61] P3B-dc3
Rdc61 P3B ndc61_1 10.6640655465
Ldc61 ndc61_1 dc3 1.17972561472e-05
* DC[62] P3B-P1B
Rdc62 P3B ndc62_1 0.670148015928
Ldc62 ndc62_1 P1B 1.06657369338e-07
* DC[64] P4B-dc1
Rdc64 P4B ndc64_1 33.1394568022
Ldc64 ndc64_1 dc1 3.0461766357e-05
* DC[65] P4B-dc2
Rdc65 P4B ndc65_1 42.9464899175
Ldc65 ndc65_1 dc2 2.85135104798e-05
* DC[68] dc0-dc1
Rdc68 dc0 ndc68_1 0.0369396503681
Ldc68 ndc68_1 dc1 3.41863812839e-08
* DC[69] dc0-dc2
Rdc69 dc0 ndc69_1 1.55638063642
Ldc69 ndc69_1 dc2 2.53878690963e-06
* DC[71] dc0-P1B
Rdc71 dc0 ndc71_1 0.0270552750829
Ldc71 ndc71_1 P1B 4.36785778598e-09
* DC[72] dc1-dc2
Rdc72 dc1 ndc72_1 1.08205105961
Ldc72 ndc72_1 dc2 7.35111096679e-06
* DC[73] dc1-dc3
Rdc73 dc1 ndc73_1 0.607170962529
Ldc73 ndc73_1 dc3 5.33133897666e-07
* DC[74] dc1-P1B
Rdc74 dc1 ndc74_1 0.145110023717
Ldc74 ndc74_1 P1B 1.00357224867e-07
* DC[75] dc2-dc3
Rdc75 dc2 ndc75_1 0.254710030967
Ldc75 ndc75_1 dc3 4.2474263178e-07
* DC[76] dc2-P1B
Rdc76 dc2 ndc76_1 0.0703507143796
Ldc76 ndc76_1 P1B 8.26488745561e-08
* DC[77] dc3-P1B
Rdc77 dc3 ndc77_1 0.0276637765373
Ldc77 ndc77_1 P1B 1.45114144601e-08
* ---- leaks
Rleak_P1A P1A P1B 1e+12
Rleak_P2A P2A P1B 1e+12
Rleak_P2B P2B P1B 1e+12
Rleak_P3A P3A P1B 1e+12
Rleak_P3B P3B P1B 1e+12
Rleak_P4A P4A P1B 1e+12
Rleak_P4B P4B P1B 1e+12
Rleak_dc0 dc0 P1B 1e+12
Rleak_dc1 dc1 P1B 1e+12
Rleak_dc2 dc2 P1B 1e+12
Rleak_dc3 dc3 P1B 1e+12
Rleak_rlc0 rlc0 P1B 1e+12
Rleak_rlc1 rlc1 P1B 1e+12
Rleak_rlc10 rlc10 P1B 1e+12
Rleak_rlc11 rlc11 P1B 1e+12
Rleak_rlc12 rlc12 P1B 1e+12
Rleak_rlc13 rlc13 P1B 1e+12
Rleak_rlc14 rlc14 P1B 1e+12
Rleak_rlc15 rlc15 P1B 1e+12
Rleak_rlc2 rlc2 P1B 1e+12
Rleak_rlc3 rlc3 P1B 1e+12
Rleak_rlc4 rlc4 P1B 1e+12
Rleak_rlc5 rlc5 P1B 1e+12
Rleak_rlc6 rlc6 P1B 1e+12
Rleak_rlc7 rlc7 P1B 1e+12
Rleak_rlc8 rlc8 P1B 1e+12
Rleak_rlc9 rlc9 P1B 1e+12
.ends fitted
