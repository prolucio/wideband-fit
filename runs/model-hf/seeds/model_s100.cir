* fitted: 4-port fitted model, reference z0 = 50 Ohm
* port p is PpA (+) to PpB (-); the reference node is P1B
.subckt fitted P1A P1B P2A P2B P3A P3B P4A P4B
* ---- branches
* RLC[0] P1A-P2A
Rrlc0 P1A nrlc0_1 3.21244530174
Lrlc0 nrlc0_1 nrlc0_2 1.00320210335e-06
Crlc0 nrlc0_2 P2A 3.32000066189e-07
* RLC[1] P1A-P3A
Rrlc1 P1A nrlc1_1 767001.074014
Lrlc1 nrlc1_1 nrlc1_2 2.01707879877e-08
Crlc1 nrlc1_2 P3A 5.66298880583e-15
* RLC[2] P1A-P4A
Rrlc2 P1A nrlc2_1 4964898.53994
Lrlc2 nrlc2_1 nrlc2_2 0.000866170539535
Crlc2 nrlc2_2 P4A 2.90284613659e-15
* RLC[4] P1A-P2B
Rrlc4 P1A nrlc4_1 3363.34299072
Lrlc4 nrlc4_1 nrlc4_2 0.000120724951421
Crlc4 nrlc4_2 P2B 1.18580209366e-14
* RLC[5] P1A-P3B
Rrlc5 P1A nrlc5_1 253311.16225
Lrlc5 nrlc5_1 nrlc5_2 4.59369665623e-10
Crlc5 nrlc5_2 P3B 3.93594362518e-12
* RLC[6] P1A-P4B
Rrlc6 P1A nrlc6_1 1253385.17933
Lrlc6 nrlc6_1 nrlc6_2 0.354278900499
Crlc6 nrlc6_2 P4B 9.12124573088e-12
* RLC[7] P1A-rlc0
Rrlc7 P1A nrlc7_1 9.63651889539
Lrlc7 nrlc7_1 nrlc7_2 6.56567345644e-08
Crlc7 nrlc7_2 rlc0 7.85590847816e-13
* RLC[8] P1A-rlc1
Rrlc8 P1A nrlc8_1 87.7218505939
Lrlc8 nrlc8_1 nrlc8_2 5.88750373837e-07
Crlc8 nrlc8_2 rlc1 8.50106068417e-14
* RLC[9] P1A-rlc2
Rrlc9 P1A nrlc9_1 943.059227247
Lrlc9 nrlc9_1 nrlc9_2 1.21208469356e-05
Crlc9 nrlc9_2 rlc2 1.51430208395e-14
* RLC[10] P1A-rlc3
Rrlc10 P1A nrlc10_1 3580.88958176
Lrlc10 nrlc10_1 nrlc10_2 9.796552524e-05
Crlc10 nrlc10_2 rlc3 1.02330792029e-14
* RLC[11] P1A-rlc4
Rrlc11 P1A nrlc11_1 165.722880356
Lrlc11 nrlc11_1 nrlc11_2 1.259655765e-06
Crlc11 nrlc11_2 rlc4 5.09617605854e-14
* RLC[14] P1A-rlc7
Rrlc14 P1A nrlc14_1 292.312088431
Lrlc14 nrlc14_1 nrlc14_2 1.97116517922e-06
Crlc14 nrlc14_2 rlc7 2.56322634256e-14
* RLC[15] P1A-rlc8
Rrlc15 P1A nrlc15_1 435.938205633
Lrlc15 nrlc15_1 nrlc15_2 2.94888494978e-06
Crlc15 nrlc15_2 rlc8 1.72411192218e-14
* RLC[16] P1A-rlc9
Rrlc16 P1A nrlc16_1 0.0192639792005
Lrlc16 nrlc16_1 nrlc16_2 2.21054901204e-12
Crlc16 nrlc16_2 rlc9 6.61859242172e-12
* RLC[17] P1A-rlc10
Rrlc17 P1A nrlc17_1 131.022938719
Lrlc17 nrlc17_1 nrlc17_2 3.29838897211e-07
Crlc17 nrlc17_2 rlc10 2.13483765963e-14
* RLC[18] P1A-rlc11
Rrlc18 P1A nrlc18_1 6074.6873389
Lrlc18 nrlc18_1 nrlc18_2 4.13797147091e-05
Crlc18 nrlc18_2 rlc11 1.24593998295e-15
* RLC[19] P1A-rlc12
Rrlc19 P1A nrlc19_1 1120.12168237
Lrlc19 nrlc19_1 nrlc19_2 7.5721554073e-06
Crlc19 nrlc19_2 rlc12 6.70573830969e-15
* RLC[20] P1A-rlc13
Rrlc20 P1A nrlc20_1 7439.41679699
Lrlc20 nrlc20_1 nrlc20_2 1.36225433787e-05
Crlc20 nrlc20_2 rlc13 1.81016444957e-14
* RLC[21] P1A-rlc14
Rrlc21 P1A nrlc21_1 229940.256687
Lrlc21 nrlc21_1 nrlc21_2 0.00432010371375
Crlc21 nrlc21_2 rlc14 2.67462916742e-14
* RLC[22] P1A-rlc15
Rrlc22 P1A nrlc22_1 2761.39913929
Lrlc22 nrlc22_1 nrlc22_2 1.88038700111e-05
Crlc22 nrlc22_2 rlc15 2.73997348775e-15
* RLC[24] P2A-P3A
Rrlc24 P2A nrlc24_1 614486642.957
Lrlc24 nrlc24_1 nrlc24_2 0.436546278687
Crlc24 nrlc24_2 P3A 7.66322703381e-06
* RLC[26] P2A-P1B
Rrlc26 P2A nrlc26_1 299395.920608
Lrlc26 nrlc26_1 nrlc26_2 0.999982365506
Crlc26 nrlc26_2 P1B 0.000672188834927
* RLC[28] P2A-P3B
Rrlc28 P2A nrlc28_1 649698.064993
Lrlc28 nrlc28_1 nrlc28_2 1.00668398534e-07
Crlc28 nrlc28_2 P3B 1.72813392503e-11
* RLC[29] P2A-P4B
Rrlc29 P2A nrlc29_1 1300986.34269
Lrlc29 nrlc29_1 nrlc29_2 1.17353120557e-07
Crlc29 nrlc29_2 P4B 8.87040829077e-12
* RLC[31] P2A-rlc1
Rrlc31 P2A nrlc31_1 17840.0914645
Lrlc31 nrlc31_1 nrlc31_2 2.79905050724e-05
Crlc31 nrlc31_2 rlc1 2.30695968907e-13
* RLC[32] P2A-rlc2
Rrlc32 P2A nrlc32_1 925127.839745
Lrlc32 nrlc32_1 nrlc32_2 1
Crlc32 nrlc32_2 rlc2 1.39179395568e-12
* RLC[34] P2A-rlc4
Rrlc34 P2A nrlc34_1 1339095.9785
Lrlc34 nrlc34_1 nrlc34_2 0.0149735742515
Crlc34 nrlc34_2 rlc4 3.8054443784e-15
* RLC[40] P2A-rlc10
Rrlc40 P2A nrlc40_1 1033.68907739
Lrlc40 nrlc40_1 nrlc40_2 4.37566409354e-14
Crlc40 nrlc40_2 rlc10 7.71013499425e-15
* RLC[41] P2A-rlc11
Rrlc41 P2A nrlc41_1 212.106094404
Lrlc41 nrlc41_1 nrlc41_2 3.02823571294e-08
Crlc41 nrlc41_2 rlc11 1.13675435478e-13
* RLC[43] P2A-rlc13
Rrlc43 P2A nrlc43_1 2.43989531482
Lrlc43 nrlc43_1 nrlc43_2 2.23205951297e-08
Crlc43 nrlc43_2 rlc13 4.16601543191e-12
* RLC[44] P2A-rlc14
Rrlc44 P2A nrlc44_1 51.0210593462
Lrlc44 nrlc44_1 nrlc44_2 1.28197164814e-07
Crlc44 nrlc44_2 rlc14 5.47188508117e-14
* RLC[45] P2A-rlc15
Rrlc45 P2A nrlc45_1 3.3714339936
Lrlc45 nrlc45_1 nrlc45_2 7.96478412047e-09
Crlc45 nrlc45_2 rlc15 7.78578087738e-13
* RLC[48] P3A-P1B
Rrlc48 P3A nrlc48_1 13870.7640748
Lrlc48 nrlc48_1 nrlc48_2 3.3101063679e-05
Crlc48 nrlc48_2 P1B 5.90267948441e-15
* RLC[50] P3A-P3B
Rrlc50 P3A nrlc50_1 3.99688254454
Lrlc50 nrlc50_1 nrlc50_2 1.26262275121e-08
Crlc50 nrlc50_2 P3B 8.78189680193e-13
* RLC[51] P3A-P4B
Rrlc51 P3A nrlc51_1 4.6838169158
Lrlc51 nrlc51_1 nrlc51_2 1.97697518721e-08
Crlc51 nrlc51_2 P4B 1.00128771478e-12
* RLC[57] P3A-rlc5
Rrlc57 P3A nrlc57_1 61.8213325254
Lrlc57 nrlc57_1 nrlc57_2 8.74317120084e-07
Crlc57 nrlc57_2 rlc5 2.54184901112e-13
* RLC[59] P3A-rlc7
Rrlc59 P3A nrlc59_1 6130.60892961
Lrlc59 nrlc59_1 nrlc59_2 2.44872037416e-05
Crlc59 nrlc59_2 rlc7 6.31340697273e-14
* RLC[60] P3A-rlc8
Rrlc60 P3A nrlc60_1 8.94209812729
Lrlc60 nrlc60_1 nrlc60_2 3.6847299719e-08
Crlc60 nrlc60_2 rlc8 5.12016898789e-13
* RLC[62] P3A-rlc10
Rrlc62 P3A nrlc62_1 3.98629807968
Lrlc62 nrlc62_1 nrlc62_2 3.16606344169e-08
Crlc62 nrlc62_2 rlc10 2.21379581831e-12
* RLC[63] P3A-rlc11
Rrlc63 P3A nrlc63_1 11859.0955671
Lrlc63 nrlc63_1 nrlc63_2 4.6607600996e-05
Crlc63 nrlc63_2 rlc11 7.28364581199e-14
* RLC[66] P3A-rlc14
Rrlc66 P3A nrlc66_1 2.49366948551
Lrlc66 nrlc66_1 nrlc66_2 3.50753179354e-08
Crlc66 nrlc66_2 rlc14 6.26731213924e-12
* RLC[67] P3A-rlc15
Rrlc67 P3A nrlc67_1 1138.20713846
Lrlc67 nrlc67_1 nrlc67_2 1.67380943174e-05
Crlc67 nrlc67_2 rlc15 1.43555848755e-14
* RLC[68] P3A-P1B
Rrlc68 P3A nrlc68_1 81932.0327254
Lrlc68 nrlc68_1 nrlc68_2 0.000121235027067
Crlc68 nrlc68_2 P1B 2.11392338473e-13
* RLC[70] P4A-P2B
Rrlc70 P4A nrlc70_1 115.303281336
Lrlc70 nrlc70_1 nrlc70_2 3.78180852533e-07
Crlc70 nrlc70_2 P2B 3.1606302589e-14
* RLC[72] P4A-P4B
Rrlc72 P4A nrlc72_1 4.24709050812
Lrlc72 nrlc72_1 nrlc72_2 1.40086405483e-08
Crlc72 nrlc72_2 P4B 8.62919831427e-13
* RLC[73] P4A-rlc0
Rrlc73 P4A nrlc73_1 11299.2488383
Lrlc73 nrlc73_1 nrlc73_2 0.000711853476903
Crlc73 nrlc73_2 rlc0 6.19510904474e-15
* RLC[74] P4A-rlc1
Rrlc74 P4A nrlc74_1 5344.30890207
Lrlc74 nrlc74_1 nrlc74_2 8.75191054727e-06
Crlc74 nrlc74_2 rlc1 4.50639879154e-14
* RLC[77] P4A-rlc4
Rrlc77 P4A nrlc77_1 310001.976989
Lrlc77 nrlc77_1 nrlc77_2 0.0149117702769
Crlc77 nrlc77_2 rlc4 7.01786338749e-12
* RLC[82] P4A-rlc9
Rrlc82 P4A nrlc82_1 15979.6646305
Lrlc82 nrlc82_1 nrlc82_2 4.42619559639e-05
Crlc82 nrlc82_2 rlc9 2.23952051814e-14
* RLC[83] P4A-rlc10
Rrlc83 P4A nrlc83_1 0.406460358226
Lrlc83 nrlc83_1 nrlc83_2 2.28427058555e-09
Crlc83 nrlc83_2 rlc10 1.5362738805e-11
* RLC[84] P4A-rlc11
Rrlc84 P4A nrlc84_1 326357.919322
Lrlc84 nrlc84_1 nrlc84_2 0.484494839987
Crlc84 nrlc84_2 rlc11 4.04332273246e-11
* RLC[86] P4A-rlc13
Rrlc86 P4A nrlc86_1 328272.661317
Lrlc86 nrlc86_1 nrlc86_2 0.00937365908102
Crlc86 nrlc86_2 rlc13 5.02269869426e-12
* RLC[90] P1B-P2B
Rrlc90 P1B nrlc90_1 39.0085441056
Lrlc90 nrlc90_1 nrlc90_2 1.47720567152e-05
Crlc90 nrlc90_2 P2B 5.41272394627e-09
* RLC[93] P1B-rlc0
Rrlc93 P1B nrlc93_1 2479.58679885
Lrlc93 nrlc93_1 nrlc93_2 2.04156167312e-05
Crlc93 nrlc93_2 rlc0 6.63885401624e-13
* RLC[97] P1B-rlc4
Rrlc97 P1B nrlc97_1 36410.4150324
Lrlc97 nrlc97_1 nrlc97_2 0.000156822413709
Crlc97 nrlc97_2 rlc4 1.47277161372e-15
* RLC[101] P1B-rlc8
Rrlc101 P1B nrlc101_1 2010.71974887
Lrlc101 nrlc101_1 nrlc101_2 1.09132515011e-05
Crlc101 nrlc101_2 rlc8 8.81142736036e-13
* RLC[103] P1B-rlc10
Rrlc103 P1B nrlc103_1 64442.0078503
Lrlc103 nrlc103_1 nrlc103_2 0.000121877985017
Crlc103 nrlc103_2 rlc10 4.21163191527e-09
* RLC[106] P1B-rlc13
Rrlc106 P1B nrlc106_1 138.04111841
Lrlc106 nrlc106_1 nrlc106_2 2.51271826476e-06
Crlc106 nrlc106_2 rlc13 1.46515762166e-13
* RLC[107] P1B-rlc14
Rrlc107 P1B nrlc107_1 14.6423111913
Lrlc107 nrlc107_1 nrlc107_2 4.80379553201e-08
Crlc107 nrlc107_2 rlc14 2.48956081217e-13
* RLC[110] P2B-P3B
Rrlc110 P2B nrlc110_1 15.7610027766
Lrlc110 nrlc110_1 nrlc110_2 4.10905938548e-08
Crlc110 nrlc110_2 P3B 1.83794375682e-13
* RLC[111] P2B-P4B
Rrlc111 P2B nrlc111_1 0.0394929504503
Lrlc111 nrlc111_1 nrlc111_2 1.71974516008e-10
Crlc111 nrlc111_2 P4B 1.22513347481e-10
* RLC[114] P2B-rlc2
Rrlc114 P2B nrlc114_1 0.0556918343456
Lrlc114 nrlc114_1 nrlc114_2 2.62643587613e-10
Crlc114 nrlc114_2 rlc2 9.40895187679e-11
* RLC[115] P2B-rlc3
Rrlc115 P2B nrlc115_1 35.3389722946
Lrlc115 nrlc115_1 nrlc115_2 1.35117054671e-07
Crlc115 nrlc115_2 rlc3 6.63067808858e-11
* RLC[116] P2B-rlc4
Rrlc116 P2B nrlc116_1 4.34873540817
Lrlc116 nrlc116_1 nrlc116_2 3.32896323659e-08
Crlc116 nrlc116_2 rlc4 1.95587241047e-12
* RLC[117] P2B-rlc5
Rrlc117 P2B nrlc117_1 175.572662803
Lrlc117 nrlc117_1 nrlc117_2 4.48302961349e-06
Crlc117 nrlc117_2 rlc5 9.06160631658e-13
* RLC[119] P2B-rlc7
Rrlc119 P2B nrlc119_1 12.3011564342
Lrlc119 nrlc119_1 nrlc119_2 2.12145715547e-07
Crlc119 nrlc119_2 rlc7 1.55775757889e-12
* RLC[121] P2B-rlc9
Rrlc121 P2B nrlc121_1 8.56291296679
Lrlc121 nrlc121_1 nrlc121_2 6.09143279947e-08
Crlc121 nrlc121_2 rlc9 6.01985635229e-11
* RLC[122] P2B-rlc10
Rrlc122 P2B nrlc122_1 6506.57380526
Lrlc122 nrlc122_1 nrlc122_2 4.23979352928e-05
Crlc122 nrlc122_2 rlc10 2.00912635059e-13
* RLC[123] P2B-rlc11
Rrlc123 P2B nrlc123_1 7.77608455721
Lrlc123 nrlc123_1 nrlc123_2 1.02521651346e-07
Crlc123 nrlc123_2 rlc11 1.64900729742e-05
* RLC[124] P2B-rlc12
Rrlc124 P2B nrlc124_1 4.75906588007
Lrlc124 nrlc124_1 nrlc124_2 6.50248235854e-15
Crlc124 nrlc124_2 rlc12 0.001
* RLC[126] P2B-rlc14
Rrlc126 P2B nrlc126_1 133.938964347
Lrlc126 nrlc126_1 nrlc126_2 4.4396902102e-07
Crlc126 nrlc126_2 rlc14 2.36701810712e-13
* RLC[129] P3B-P4B
Rrlc129 P3B nrlc129_1 6.35190877295
Lrlc129 nrlc129_1 nrlc129_2 2.98108788562e-06
Crlc129 nrlc129_2 P4B 0.001
* RLC[131] P3B-rlc1
Rrlc131 P3B nrlc131_1 0.01
Lrlc131 nrlc131_1 nrlc131_2 1.13454790314e-06
Crlc131 nrlc131_2 rlc1 0.001
* RLC[133] P3B-rlc3
Rrlc133 P3B nrlc133_1 14409.7735265
Lrlc133 nrlc133_1 nrlc133_2 4.88292651285e-05
Crlc133 nrlc133_2 rlc3 4.17639668115e-15
* RLC[134] P3B-rlc4
Rrlc134 P3B nrlc134_1 0.01
Lrlc134 nrlc134_1 nrlc134_2 1.77949582317e-13
Crlc134 nrlc134_2 rlc4 1.89893248692e-11
* RLC[135] P3B-rlc5
Rrlc135 P3B nrlc135_1 50.7215464377
Lrlc135 nrlc135_1 nrlc135_2 1.01159259904e-07
Crlc135 nrlc135_2 rlc5 4.36896093534e-14
* RLC[136] P3B-rlc6
Rrlc136 P3B nrlc136_1 24.1859237869
Lrlc136 nrlc136_1 nrlc136_2 5.13530697043e-06
Crlc136 nrlc136_2 rlc6 7.33234777002e-08
* RLC[137] P3B-rlc7
Rrlc137 P3B nrlc137_1 843.027098502
Lrlc137 nrlc137_1 nrlc137_2 6.0942100622e-06
Crlc137 nrlc137_2 rlc7 9.52778263323e-15
* RLC[138] P3B-rlc8
Rrlc138 P3B nrlc138_1 0.195749141673
Lrlc138 nrlc138_1 nrlc138_2 6.84966074417e-08
Crlc138 nrlc138_2 rlc8 0.001
* RLC[141] P3B-rlc11
Rrlc141 P3B nrlc141_1 1184.18147883
Lrlc141 nrlc141_1 nrlc141_2 8.28181121533e-06
Crlc141 nrlc141_2 rlc11 6.56215204258e-15
* RLC[143] P3B-rlc13
Rrlc143 P3B nrlc143_1 279.816435408
Lrlc143 nrlc143_1 nrlc143_2 8.98743315216e-07
Crlc143 nrlc143_2 rlc13 1.2754009147e-14
* RLC[144] P3B-rlc14
Rrlc144 P3B nrlc144_1 480.114698807
Lrlc144 nrlc144_1 nrlc144_2 1.06529770825e-06
Crlc144 nrlc144_2 rlc14 5.13497671898e-15
* RLC[145] P3B-rlc15
Rrlc145 P3B nrlc145_1 1115.21451425
Lrlc145 nrlc145_1 nrlc145_2 7.757935919e-06
Crlc145 nrlc145_2 rlc15 6.93085562856e-15
* RLC[146] P3B-P1B
Rrlc146 P3B nrlc146_1 584.479306377
Lrlc146 nrlc146_1 nrlc146_2 7.61716329813e-05
Crlc146 nrlc146_2 P1B 2.41832219208e-10
* RLC[148] P4B-rlc1
Rrlc148 P4B nrlc148_1 91.3475688452
Lrlc148 nrlc148_1 nrlc148_2 5.22994543233e-06
Crlc148 nrlc148_2 rlc1 3.11757547065e-10
* RLC[149] P4B-rlc2
Rrlc149 P4B nrlc149_1 27.7321392835
Lrlc149 nrlc149_1 nrlc149_2 4.97504510025e-07
Crlc149 nrlc149_2 rlc2 9.94206059695e-10
* RLC[150] P4B-rlc3
Rrlc150 P4B nrlc150_1 0.0150706510301
Lrlc150 nrlc150_1 nrlc150_2 1.43939322359e-10
Crlc150 nrlc150_2 rlc3 2.27063062885e-06
* RLC[155] P4B-rlc8
Rrlc155 P4B nrlc155_1 0.0143246649965
Lrlc155 nrlc155_1 nrlc155_2 7.55869462202e-10
Crlc155 nrlc155_2 rlc8 0.001
* RLC[156] P4B-rlc9
Rrlc156 P4B nrlc156_1 9.23897330363
Lrlc156 nrlc156_1 nrlc156_2 1.84442932789e-07
Crlc156 nrlc156_2 rlc9 2.40088901963e-12
* RLC[158] P4B-rlc11
Rrlc158 P4B nrlc158_1 83.4505918236
Lrlc158 nrlc158_1 nrlc158_2 6.91372805911e-07
Crlc158 nrlc158_2 rlc11 3.62806897203e-11
* RLC[159] P4B-rlc12
Rrlc159 P4B nrlc159_1 2.40129056986
Lrlc159 nrlc159_1 nrlc159_2 8.96403931149e-10
Crlc159 nrlc159_2 rlc12 1.77357493813e-11
* RLC[160] P4B-rlc13
Rrlc160 P4B nrlc160_1 0.796898734926
Lrlc160 nrlc160_1 nrlc160_2 1.32300969843e-09
Crlc160 nrlc160_2 rlc13 2.31480410374e-12
* RLC[161] P4B-rlc14
Rrlc161 P4B nrlc161_1 0.0853287379418
Lrlc161 nrlc161_1 nrlc161_2 2.27160449174e-09
Crlc161 nrlc161_2 rlc14 3.46658411113e-10
* RLC[162] P4B-rlc15
Rrlc162 P4B nrlc162_1 8.29718621373
Lrlc162 nrlc162_1 nrlc162_2 1.63237835847e-08
Crlc162 nrlc162_2 rlc15 3.29108675883e-12
* RLC[164] rlc0-rlc1
Rrlc164 rlc0 nrlc164_1 0.01
Lrlc164 nrlc164_1 nrlc164_2 6.2280836597e-09
Crlc164 nrlc164_2 rlc1 6.39561796462e-05
* RLC[165] rlc0-rlc2
Rrlc165 rlc0 nrlc165_1 0.01
Lrlc165 nrlc165_1 nrlc165_2 6.80140902735e-12
Crlc165 nrlc165_2 rlc2 7.44975424163e-09
* RLC[167] rlc0-rlc4
Rrlc167 rlc0 nrlc167_1 86239.1063985
Lrlc167 nrlc167_1 nrlc167_2 0.000882391294693
Crlc167 nrlc167_2 rlc4 7.22977496961e-13
* RLC[168] rlc0-rlc5
Rrlc168 rlc0 nrlc168_1 17047.6347905
Lrlc168 nrlc168_1 nrlc168_2 1.01157982157e-07
Crlc168 nrlc168_2 rlc5 2.72563965591e-11
* RLC[170] rlc0-rlc7
Rrlc170 rlc0 nrlc170_1 1.20041912896
Lrlc170 nrlc170_1 nrlc170_2 7.79994499502e-09
Crlc170 nrlc170_2 rlc7 3.51977973518e-08
* RLC[171] rlc0-rlc8
Rrlc171 rlc0 nrlc171_1 17.273118431
Lrlc171 nrlc171_1 nrlc171_2 2.65799111842e-07
Crlc171 nrlc171_2 rlc8 3.20528998808e-12
* RLC[172] rlc0-rlc9
Rrlc172 rlc0 nrlc172_1 33.8971749468
Lrlc172 nrlc172_1 nrlc172_2 1.01601561459e-06
Crlc172 nrlc172_2 rlc9 9.82496163919e-13
* RLC[173] rlc0-rlc10
Rrlc173 rlc0 nrlc173_1 1205190.11419
Lrlc173 nrlc173_1 nrlc173_2 1
Crlc173 nrlc173_2 rlc10 6.8968589374e-13
* RLC[177] rlc0-rlc14
Rrlc177 rlc0 nrlc177_1 241.076410117
Lrlc177 nrlc177_1 nrlc177_2 1.0197513811e-07
Crlc177 nrlc177_2 rlc14 3.81755678821e-13
* RLC[178] rlc0-rlc15
Rrlc178 rlc0 nrlc178_1 33.0645142889
Lrlc178 nrlc178_1 nrlc178_2 3.58812675517e-07
Crlc178 nrlc178_2 rlc15 7.57374679224e-09
* RLC[182] rlc1-rlc4
Rrlc182 rlc1 nrlc182_1 59.9099817873
Lrlc182 nrlc182_1 nrlc182_2 4.50737455636e-07
Crlc182 nrlc182_2 rlc4 1.39534873905e-13
* RLC[183] rlc1-rlc5
Rrlc183 rlc1 nrlc183_1 0.520833548891
Lrlc183 nrlc183_1 nrlc183_2 2.57177527023e-09
Crlc183 nrlc183_2 rlc5 1.05339827874e-11
* RLC[184] rlc1-rlc6
Rrlc184 rlc1 nrlc184_1 27.5454086358
Lrlc184 nrlc184_1 nrlc184_2 1.17665300998e-08
Crlc184 nrlc184_2 rlc6 7.81676595171e-12
* RLC[185] rlc1-rlc7
Rrlc185 rlc1 nrlc185_1 4.67852772294
Lrlc185 nrlc185_1 nrlc185_2 5.19702618244e-07
Crlc185 nrlc185_2 rlc7 2.62026786485e-07
* RLC[187] rlc1-rlc9
Rrlc187 rlc1 nrlc187_1 122.490263054
Lrlc187 nrlc187_1 nrlc187_2 2.63099028652e-07
Crlc187 nrlc187_2 rlc9 3.22667318055e-10
* RLC[189] rlc1-rlc11
Rrlc189 rlc1 nrlc189_1 42.7780017192
Lrlc189 nrlc189_1 nrlc189_2 7.06453477245e-07
Crlc189 nrlc189_2 rlc11 4.28943479621e-13
* RLC[193] rlc1-rlc15
Rrlc193 rlc1 nrlc193_1 69.3781809074
Lrlc193 nrlc193_1 nrlc193_2 4.55189280857e-07
Crlc193 nrlc193_2 rlc15 1.0507604069e-13
* RLC[194] rlc1-P1B
Rrlc194 rlc1 nrlc194_1 1075.82068538
Lrlc194 nrlc194_1 nrlc194_2 8.10730382278e-06
Crlc194 nrlc194_2 P1B 6.86540130526e-12
* RLC[195] rlc2-rlc3
Rrlc195 rlc2 nrlc195_1 1.8026613539
Lrlc195 nrlc195_1 nrlc195_2 9.57135493895e-09
Crlc195 nrlc195_2 rlc3 3.2726780524e-12
* RLC[196] rlc2-rlc4
Rrlc196 rlc2 nrlc196_1 31286.2230319
Lrlc196 nrlc196_1 nrlc196_2 0.000321733424181
Crlc196 nrlc196_2 rlc4 2.58799994743e-13
* RLC[197] rlc2-rlc5
Rrlc197 rlc2 nrlc197_1 10.4967025661
Lrlc197 nrlc197_1 nrlc197_2 1.24719140579e-08
Crlc197 nrlc197_2 rlc5 1.89941970666e-12
* RLC[198] rlc2-rlc6
Rrlc198 rlc2 nrlc198_1 44.3662362267
Lrlc198 nrlc198_1 nrlc198_2 1.6286550189e-07
Crlc198 nrlc198_2 rlc6 1.58256877746e-08
* RLC[201] rlc2-rlc9
Rrlc201 rlc2 nrlc201_1 0.636620148868
Lrlc201 nrlc201_1 nrlc201_2 2.11398976722e-08
Crlc201 nrlc201_2 rlc9 5.79561612001e-11
* RLC[202] rlc2-rlc10
Rrlc202 rlc2 nrlc202_1 9289.87242131
Lrlc202 nrlc202_1 nrlc202_2 0.000125782033805
Crlc202 nrlc202_2 rlc10 4.51358244643e-14
* RLC[204] rlc2-rlc12
Rrlc204 rlc2 nrlc204_1 25.815086202
Lrlc204 nrlc204_1 nrlc204_2 3.65006470612e-07
Crlc204 nrlc204_2 rlc12 3.61725335324e-12
* RLC[205] rlc2-rlc13
Rrlc205 rlc2 nrlc205_1 4350.34048338
Lrlc205 nrlc205_1 nrlc205_2 0.000305681896663
Crlc205 nrlc205_2 rlc13 0.000139749817212
* RLC[207] rlc2-rlc15
Rrlc207 rlc2 nrlc207_1 17.0981304879
Lrlc207 nrlc207_1 nrlc207_2 9.93087920239e-08
Crlc207 nrlc207_2 rlc15 3.97347734088e-10
* RLC[208] rlc2-P1B
Rrlc208 rlc2 nrlc208_1 2.58591349307
Lrlc208 nrlc208_1 nrlc208_2 7.9149010167e-09
Crlc208 nrlc208_2 P1B 1.31514910573e-12
* RLC[209] rlc3-rlc4
Rrlc209 rlc3 nrlc209_1 84718.5881494
Lrlc209 nrlc209_1 nrlc209_2 0.00415506631134
Crlc209 nrlc209_2 rlc4 1.57700390079e-06
* RLC[212] rlc3-rlc7
Rrlc212 rlc3 nrlc212_1 3.81010438308
Lrlc212 nrlc212_1 nrlc212_2 1.38938596306e-07
Crlc212 nrlc212_2 rlc7 1.47416212818e-07
* RLC[216] rlc3-rlc11
Rrlc216 rlc3 nrlc216_1 9.25700082051
Lrlc216 nrlc216_1 nrlc216_2 1.24993450739e-08
Crlc216 nrlc216_2 rlc11 2.90772064293e-11
* RLC[219] rlc3-rlc14
Rrlc219 rlc3 nrlc219_1 48.8003249948
Lrlc219 nrlc219_1 nrlc219_2 1.45715211124e-06
Crlc219 nrlc219_2 rlc14 6.79856026865e-13
* RLC[220] rlc3-rlc15
Rrlc220 rlc3 nrlc220_1 1.81674071192
Lrlc220 nrlc220_1 nrlc220_2 4.01839700886e-08
Crlc220 nrlc220_2 rlc15 0.000364884158634
* RLC[221] rlc3-P1B
Rrlc221 rlc3 nrlc221_1 2472.17099119
Lrlc221 nrlc221_1 nrlc221_2 1.48980249477e-05
Crlc221 nrlc221_2 P1B 3.17819784791e-13
* RLC[225] rlc4-rlc8
Rrlc225 rlc4 nrlc225_1 55.2966809657
Lrlc225 nrlc225_1 nrlc225_2 1.22838447251e-07
Crlc225 nrlc225_2 rlc8 4.46368644e-14
* RLC[226] rlc4-rlc9
Rrlc226 rlc4 nrlc226_1 77050.6787523
Lrlc226 nrlc226_1 nrlc226_2 0.000558383069276
Crlc226 nrlc226_2 rlc9 2.71039106496e-13
* RLC[227] rlc4-rlc10
Rrlc227 rlc4 nrlc227_1 0.213751281956
Lrlc227 nrlc227_1 nrlc227_2 2.3099789674e-08
Crlc227 nrlc227_2 rlc10 8.58748485266e-09
* RLC[228] rlc4-rlc11
Rrlc228 rlc4 nrlc228_1 29.2276219858
Lrlc228 nrlc228_1 nrlc228_2 2.23563394493e-07
Crlc228 nrlc228_2 rlc11 2.90784479245e-13
* RLC[229] rlc4-rlc12
Rrlc229 rlc4 nrlc229_1 54.8927749618
Lrlc229 nrlc229_1 nrlc229_2 1.20720660253e-07
Crlc229 nrlc229_2 rlc12 4.45152401528e-14
* RLC[232] rlc4-rlc15
Rrlc232 rlc4 nrlc232_1 177.789661149
Lrlc232 nrlc232_1 nrlc232_2 5.46650547408e-07
Crlc232 nrlc232_2 rlc15 1.92156143259e-14
* RLC[233] rlc4-P1B
Rrlc233 rlc4 nrlc233_1 325.095223726
Lrlc233 nrlc233_1 nrlc233_2 5.0531079645e-08
Crlc233 nrlc233_2 P1B 6.15887699469e-14
* RLC[235] rlc5-rlc7
Rrlc235 rlc5 nrlc235_1 15.816502499
Lrlc235 nrlc235_1 nrlc235_2 7.15154786695e-08
Crlc235 nrlc235_2 rlc7 3.44404252098e-13
* RLC[236] rlc5-rlc8
Rrlc236 rlc5 nrlc236_1 24.0441821606
Lrlc236 nrlc236_1 nrlc236_2 2.47924272938e-09
Crlc236 nrlc236_2 rlc8 1.19880900725e-08
* RLC[237] rlc5-rlc9
Rrlc237 rlc5 nrlc237_1 84.5972300497
Lrlc237 nrlc237_1 nrlc237_2 4.4278965483e-06
Crlc237 nrlc237_2 rlc9 0.000361482273598
* RLC[238] rlc5-rlc10
Rrlc238 rlc5 nrlc238_1 15.4589858763
Lrlc238 nrlc238_1 nrlc238_2 4.20323431481e-08
Crlc238 nrlc238_2 rlc10 1.95424536575e-13
* RLC[240] rlc5-rlc12
Rrlc240 rlc5 nrlc240_1 2.61528858567
Lrlc240 nrlc240_1 nrlc240_2 4.74722169186e-08
Crlc240 nrlc240_2 rlc12 1.37074008101e-07
* RLC[242] rlc5-rlc14
Rrlc242 rlc5 nrlc242_1 1329.85262217
Lrlc242 nrlc242_1 nrlc242_2 3.07580296008e-05
Crlc242 nrlc242_2 rlc14 1.93245314747e-14
* RLC[243] rlc5-rlc15
Rrlc243 rlc5 nrlc243_1 84.2787941747
Lrlc243 nrlc243_1 nrlc243_2 4.77004406499e-09
Crlc243 nrlc243_2 rlc15 3.07752163973e-13
* RLC[244] rlc5-P1B
Rrlc244 rlc5 nrlc244_1 7.73021015397
Lrlc244 nrlc244_1 nrlc244_2 2.33363538788e-08
Crlc244 nrlc244_2 P1B 4.33918224498e-13
* RLC[245] rlc6-rlc7
Rrlc245 rlc6 nrlc245_1 2239.6495766
Lrlc245 nrlc245_1 nrlc245_2 8.1561477421e-06
Crlc245 nrlc245_2 rlc7 6.8086280266e-11
* RLC[246] rlc6-rlc8
Rrlc246 rlc6 nrlc246_1 0.0372761810658
Lrlc246 nrlc246_1 nrlc246_2 4.29785074101e-11
Crlc246 nrlc246_2 rlc8 3.43673459187e-11
* RLC[247] rlc6-rlc9
Rrlc247 rlc6 nrlc247_1 28.5460905431
Lrlc247 nrlc247_1 nrlc247_2 2.15143458142e-07
Crlc247 nrlc247_2 rlc9 1.46394498121e-11
* RLC[248] rlc6-rlc10
Rrlc248 rlc6 nrlc248_1 6507.57397098
Lrlc248 nrlc248_1 nrlc248_2 4.06606945949e-05
Crlc248 nrlc248_2 rlc10 4.05062619016e-13
* RLC[249] rlc6-rlc11
Rrlc249 rlc6 nrlc249_1 0.343044676219
Lrlc249 nrlc249_1 nrlc249_2 3.80549169597e-09
Crlc249 nrlc249_2 rlc11 3.59308012121e-11
* RLC[254] rlc6-P1B
Rrlc254 rlc6 nrlc254_1 3.69853681296
Lrlc254 nrlc254_1 nrlc254_2 5.3334081688e-06
Crlc254 nrlc254_2 P1B 3.04456114435e-06
* RLC[255] rlc7-rlc8
Rrlc255 rlc7 nrlc255_1 337.280267957
Lrlc255 nrlc255_1 nrlc255_2 9.07288010627e-06
Crlc255 nrlc255_2 rlc8 1.798731272e-13
* RLC[256] rlc7-rlc9
Rrlc256 rlc7 nrlc256_1 353.966057339
Lrlc256 nrlc256_1 nrlc256_2 1.2415394954e-05
Crlc256 nrlc256_2 rlc9 1.10101894878e-13
* RLC[258] rlc7-rlc11
Rrlc258 rlc7 nrlc258_1 42.7769134656
Lrlc258 nrlc258_1 nrlc258_2 2.02364918786e-07
Crlc258 nrlc258_2 rlc11 1.07949287571e-12
* RLC[259] rlc7-rlc12
Rrlc259 rlc7 nrlc259_1 1.92229626183
Lrlc259 nrlc259_1 nrlc259_2 4.86010052685e-11
Crlc259 nrlc259_2 rlc12 5.37064644539e-11
* RLC[261] rlc7-rlc14
Rrlc261 rlc7 nrlc261_1 349.065368273
Lrlc261 nrlc261_1 nrlc261_2 8.30541957011e-07
Crlc261 nrlc261_2 rlc14 2.08998281628e-13
* RLC[262] rlc7-rlc15
Rrlc262 rlc7 nrlc262_1 16.1986197957
Lrlc262 nrlc262_1 nrlc262_2 1.0661152875e-07
Crlc262 nrlc262_2 rlc15 3.52257889945e-12
* RLC[263] rlc7-P1B
Rrlc263 rlc7 nrlc263_1 3669.86816184
Lrlc263 nrlc263_1 nrlc263_2 4.31465922361e-05
Crlc263 nrlc263_2 P1B 1.94760549447e-13
* RLC[264] rlc8-rlc9
Rrlc264 rlc8 nrlc264_1 26.4087456328
Lrlc264 nrlc264_1 nrlc264_2 1.46388031203e-07
Crlc264 nrlc264_2 rlc9 2.84912397535e-11
* RLC[266] rlc8-rlc11
Rrlc266 rlc8 nrlc266_1 329.069897849
Lrlc266 nrlc266_1 nrlc266_2 9.35766443727e-07
Crlc266 nrlc266_2 rlc11 2.77985920765e-14
* RLC[267] rlc8-rlc12
Rrlc267 rlc8 nrlc267_1 0.447375570009
Lrlc267 nrlc267_1 nrlc267_2 5.3515483699e-09
Crlc267 nrlc267_2 rlc12 2.97092997943e-11
* RLC[269] rlc8-rlc14
Rrlc269 rlc8 nrlc269_1 1.92477600585
Lrlc269 nrlc269_1 nrlc269_2 5.76211875971e-08
Crlc269 nrlc269_2 rlc14 1.72814151488e-11
* RLC[270] rlc8-rlc15
Rrlc270 rlc8 nrlc270_1 43.4986643296
Lrlc270 nrlc270_1 nrlc270_2 1.41969216303e-06
Crlc270 nrlc270_2 rlc15 2.91702963557e-10
* RLC[273] rlc9-rlc11
Rrlc273 rlc9 nrlc273_1 0.997480894454
Lrlc273 nrlc273_1 nrlc273_2 1.71880370528e-09
Crlc273 nrlc273_2 rlc11 1.9194402594e-12
* RLC[274] rlc9-rlc12
Rrlc274 rlc9 nrlc274_1 0.40058369923
Lrlc274 nrlc274_1 nrlc274_2 2.15765828621e-08
Crlc274 nrlc274_2 rlc12 2.51018870752e-10
* RLC[276] rlc9-rlc14
Rrlc276 rlc9 nrlc276_1 0.508695810796
Lrlc276 nrlc276_1 nrlc276_2 2.59618919316e-08
Crlc276 nrlc276_2 rlc14 1.11475006427e-10
* RLC[277] rlc9-rlc15
Rrlc277 rlc9 nrlc277_1 176.918999998
Lrlc277 nrlc277_1 nrlc277_2 1.14557860247e-05
Crlc277 nrlc277_2 rlc15 2.5707605741e-06
* RLC[278] rlc9-P1B
Rrlc278 rlc9 nrlc278_1 23604.4065258
Lrlc278 nrlc278_1 nrlc278_2 0.000140743211854
Crlc278 nrlc278_2 P1B 2.80671798124e-16
* RLC[279] rlc10-rlc11
Rrlc279 rlc10 nrlc279_1 6884.45984815
Lrlc279 nrlc279_1 nrlc279_2 0.000147445071068
Crlc279 nrlc279_2 rlc11 2.11070114273e-14
* RLC[280] rlc10-rlc12
Rrlc280 rlc10 nrlc280_1 10123.9977944
Lrlc280 nrlc280_1 nrlc280_2 3.86598307207e-05
Crlc280 nrlc280_2 rlc12 5.01590540204e-14
* RLC[283] rlc10-rlc15
Rrlc283 rlc10 nrlc283_1 117084.488399
Lrlc283 nrlc283_1 nrlc283_2 0.540956248319
Crlc283 nrlc283_2 rlc15 8.25481436372e-12
* RLC[284] rlc10-P1B
Rrlc284 rlc10 nrlc284_1 352047.717933
Lrlc284 nrlc284_1 nrlc284_2 0.000665748953436
Crlc284 nrlc284_2 P1B 9.43881390905e-10
* RLC[285] rlc11-rlc12
Rrlc285 rlc11 nrlc285_1 2.11528900248
Lrlc285 nrlc285_1 nrlc285_2 3.53955890149e-08
Crlc285 nrlc285_2 rlc12 6.46372208069e-10
* RLC[287] rlc11-rlc14
Rrlc287 rlc11 nrlc287_1 97.8467438053
Lrlc287 nrlc287_1 nrlc287_2 6.8348024638e-07
Crlc287 nrlc287_2 rlc14 3.67221352329e-11
* RLC[288] rlc11-rlc15
Rrlc288 rlc11 nrlc288_1 0.01
Lrlc288 nrlc288_1 nrlc288_2 3.76905893236e-10
Crlc288 nrlc288_2 rlc15 1.64498457431e-08
* RLC[291] rlc12-rlc14
Rrlc291 rlc12 nrlc291_1 13.2905252615
Lrlc291 nrlc291_1 nrlc291_2 2.92161461136e-06
Crlc291 nrlc291_2 rlc14 2.63719632765e-05
* RLC[296] rlc13-P1B
Rrlc296 rlc13 nrlc296_1 0.152276374144
Lrlc296 nrlc296_1 nrlc296_2 1.66833091282e-08
Crlc296 nrlc296_2 P1B 7.99419307366e-10
* RLC[297] rlc14-rlc15
Rrlc297 rlc14 nrlc297_1 15.074283323
Lrlc297 nrlc297_1 nrlc297_2 4.06923939271e-08
Crlc297 nrlc297_2 rlc15 1.92641881353e-08
* DC[0] P1A-P2A
Rdc0 P1A ndc0_1 0.0992805185366
Ldc0 ndc0_1 P2A 5.72541754562e-08
* DC[16] P2A-P3B
Rdc16 P2A ndc16_1 1351.25911583
Ldc16 ndc16_1 P3B 1
* DC[23] P3A-P4A
Rdc23 P3A ndc23_1 0.0173304738874
Ldc23 ndc23_1 P4A 6.42664009376e-08
* DC[24] P3A-P1B
Rdc24 P3A ndc24_1 711152.744501
Ldc24 ndc24_1 P1B 1
* DC[32] P3A-P1B
Rdc32 P3A ndc32_1 333719.844674
Ldc32 ndc32_1 P1B 1
* DC[33] P4A-P1B
Rdc33 P4A ndc33_1 244019.878214
Ldc33 ndc33_1 P1B 1
* DC[43] P1B-P3B
Rdc43 P1B ndc43_1 73.805395546
Ldc43 ndc43_1 P3B 6.05138166241e-05
* DC[46] P1B-dc1
Rdc46 P1B ndc46_1 0.185639155189
Ldc46 ndc46_1 dc1 1.86914875915e-07
* DC[48] P1B-dc3
Rdc48 P1B ndc48_1 0.0115760873337
Ldc48 ndc48_1 dc3 1.17861439062e-08
* DC[51] P2B-P4B
Rdc51 P2B ndc51_1 3.66183998943
Ldc51 ndc51_1 P4B 5.82799935129e-07
* DC[52] P2B-dc0
Rdc52 P2B ndc52_1 0.0995776605468
Ldc52 ndc52_1 dc0 8.29432520114e-08
* DC[53] P2B-dc1
Rdc53 P2B ndc53_1 0.488121249637
Ldc53 ndc53_1 dc1 4.00712686846e-07
* DC[54] P2B-dc2
Rdc54 P2B ndc54_1 0.158175477561
Ldc54 ndc54_1 dc2 1.275985554e-07
* DC[55] P2B-dc3
Rdc55 P2B ndc55_1 0.0895214800559
Ldc55 ndc55_1 dc3 7.30565847127e-08
* DC[57] P3B-P4B
Rdc57 P3B ndc57_1 0.161938979342
Ldc57 ndc57_1 P4B 2.13824292834e-05
* DC[62] P3B-P1B
Rdc62 P3B ndc62_1 1.9157561599
Ldc62 ndc62_1 P1B 1.57075544287e-06
* DC[68] dc0-dc1
Rdc68 dc0 ndc68_1 0.0310906313048
Ldc68 ndc68_1 dc1 1.89283590241e-08
* DC[69] dc0-dc2
Rdc69 dc0 ndc69_1 0.01
Ldc69 ndc69_1 dc2 2.23002803299e-09
* DC[70] dc0-dc3
Rdc70 dc0 ndc70_1 0.0119272626289
Ldc70 ndc70_1 dc3 4.75240265063e-09
* DC[74] dc1-P1B
Rdc74 dc1 ndc74_1 0.0413269195014
Ldc74 ndc74_1 P1B 4.16104258913e-08
* DC[76] dc2-P1B
Rdc76 dc2 ndc76_1 0.0143194333472
Ldc76 ndc76_1 P1B 1.55245654637e-08
* ---- leaks
Rleak_P1A P1A P1B 1e+12
Rleak_P2A P2A P1B 1e+12
Rleak_P2B P2B P1B 1e+12
Rleak_P3A P3A P1B 1e+12
Rleak_P3B P3B P1B 1e+12
Rleak_P4A P4A P1B 1e+12
Rleak_P4B P4B P1B 1e+12
Rleak_dc0 dc0 P1B 1e+12
Rleak_dc1 dc1 P1B 1e+12
Rleak_dc2 dc2 P1B 1e+12
Rleak_dc3 dc3 P1B 1e+12
Rleak_rlc0 rlc0 P1B 1e+12
Rleak_rlc1 rlc1 P1B 1e+12
Rleak_rlc10 rlc10 P1B 1e+12
Rleak_rlc11 rlc11 P1B 1e+12
Rleak_rlc12 rlc12 P1B 1e+12
Rleak_rlc13 rlc13 P1B 1e+12
Rleak_rlc14 rlc14 P1B 1e+12
Rleak_rlc15 rlc15 P1B 1e+12
Rleak_rlc2 rlc2 P1B 1e+12
Rleak_rlc3 rlc3 P1B 1e+12
Rleak_rlc4 rlc4 P1B 1e+12
Rleak_rlc5 rlc5 P1B 1e+12
Rleak_rlc6 rlc6 P1B 1e+12
Rleak_rlc7 rlc7 P1B 1e+12
Rleak_rlc8 rlc8 P1B 1e+12
Rleak_rlc9 rlc9 P1B 1e+12
.ends fitted
