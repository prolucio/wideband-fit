* fitted: 4-port fitted model, reference z0 = 50 Ohm
* port p is PpA (+) to PpB (-); the reference node is P1B
.subckt fitted P1A P1B P2A P2B P3A P3B P4A P4B
* ---- branches
* RLC[1] P1A-P3A
Rrlc1 P1A nrlc1_1 148034.278933
Lrlc1 nrlc1_1 nrlc1_2 0.000959054322219
Crlc1 nrlc1_2 P3A 1.14053530565e-15
* RLC[2] P1A-P4A
Rrlc2 P1A nrlc2_1 3829224.10549
Lrlc2 nrlc2_1 nrlc2_2 9.25110176413e-07
Crlc2 nrlc2_2 P4A 3.87961420034e-15
* RLC[3] P1A-P1B
Rrlc3 P1A nrlc3_1 2.96160294341
Lrlc3 nrlc3_1 nrlc3_2 8.91089450249e-09
Crlc3 nrlc3_2 P1B 1.12882112033e-12
* RLC[4] P1A-P2B
Rrlc4 P1A nrlc4_1 2.63137733312
Lrlc4 nrlc4_1 nrlc4_2 2.78442010268e-08
Crlc4 nrlc4_2 P2B 4.46813197623e-12
* RLC[5] P1A-P3B
Rrlc5 P1A nrlc5_1 16611.174669
Lrlc5 nrlc5_1 nrlc5_2 6.72948571585e-06
Crlc5 nrlc5_2 P3B 2.96332411395e-13
* RLC[6] P1A-P4B
Rrlc6 P1A nrlc6_1 4529019.00819
Lrlc6 nrlc6_1 nrlc6_2 0.0109498152461
Crlc6 nrlc6_2 P4B 2.66881029974e-11
* RLC[7] P1A-rlc0
Rrlc7 P1A nrlc7_1 18.6332876856
Lrlc7 nrlc7_1 nrlc7_2 6.38553047452e-08
Crlc7 nrlc7_2 rlc0 2.04350400857e-13
* RLC[9] P1A-rlc2
Rrlc9 P1A nrlc9_1 36473.0535463
Lrlc9 nrlc9_1 nrlc9_2 0.000305469552492
Crlc9 nrlc9_2 rlc2 1.0807632162e-15
* RLC[11] P1A-rlc4
Rrlc11 P1A nrlc11_1 1504345.80426
Lrlc11 nrlc11_1 nrlc11_2 0.282841523039
Crlc11 nrlc11_2 rlc4 1.56445563787e-12
* RLC[12] P1A-rlc5
Rrlc12 P1A nrlc12_1 5092.70851558
Lrlc12 nrlc12_1 nrlc12_2 0.000120806267195
Crlc12 nrlc12_2 rlc5 1.10132234285e-14
* RLC[13] P1A-rlc6
Rrlc13 P1A nrlc13_1 8025.61109203
Lrlc13 nrlc13_1 nrlc13_2 3.12325750959e-05
Crlc13 nrlc13_2 rlc6 1.06010740817e-13
* RLC[14] P1A-rlc7
Rrlc14 P1A nrlc14_1 4110.09004291
Lrlc14 nrlc14_1 nrlc14_2 9.39359546599e-07
Crlc14 nrlc14_2 rlc7 3.1339543597e-15
* RLC[15] P1A-rlc8
Rrlc15 P1A nrlc15_1 1850203.66027
Lrlc15 nrlc15_1 nrlc15_2 0.434344747931
Crlc15 nrlc15_2 rlc8 2.86905718645e-11
* RLC[16] P1A-rlc9
Rrlc16 P1A nrlc16_1 1116.31088667
Lrlc16 nrlc16_1 nrlc16_2 4.50325424504e-06
Crlc16 nrlc16_2 rlc9 4.01525967591e-15
* RLC[19] P1A-rlc12
Rrlc19 P1A nrlc19_1 22.3384668945
Lrlc19 nrlc19_1 nrlc19_2 2.80939295162e-09
Crlc19 nrlc19_2 rlc12 6.25551761494e-15
* RLC[21] P1A-rlc14
Rrlc21 P1A nrlc21_1 757367.386277
Lrlc21 nrlc21_1 nrlc21_2 1.23641496942e-06
Crlc21 nrlc21_2 rlc14 2.88530333296e-13
* RLC[24] P2A-P3A
Rrlc24 P2A nrlc24_1 6277.52969202
Lrlc24 nrlc24_1 nrlc24_2 6.58748785762e-05
Crlc24 nrlc24_2 P3A 2.31498013742e-15
* RLC[25] P2A-P4A
Rrlc25 P2A nrlc25_1 6459.53649042
Lrlc25 nrlc25_1 nrlc25_2 1.98069597697e-05
Crlc25 nrlc25_2 P4A 5.27439435782e-16
* RLC[26] P2A-P1B
Rrlc26 P2A nrlc26_1 1177.38345442
Lrlc26 nrlc26_1 nrlc26_2 4.04395652173e-06
Crlc26 nrlc26_2 P1B 1.67148882537e-13
* RLC[28] P2A-P3B
Rrlc28 P2A nrlc28_1 1772606.88462
Lrlc28 nrlc28_1 nrlc28_2 3.30509384735e-06
Crlc28 nrlc28_2 P3B 1.93671074184e-09
* RLC[29] P2A-P4B
Rrlc29 P2A nrlc29_1 748202.925104
Lrlc29 nrlc29_1 nrlc29_2 0.00153073655058
Crlc29 nrlc29_2 P4B 1.9914549885e-10
* RLC[30] P2A-rlc0
Rrlc30 P2A nrlc30_1 338064.044772
Lrlc30 nrlc30_1 nrlc30_2 0.83952010383
Crlc30 nrlc30_2 rlc0 6.08495886139e-10
* RLC[31] P2A-rlc1
Rrlc31 P2A nrlc31_1 63149.9117058
Lrlc31 nrlc31_1 nrlc31_2 5.49171660228e-05
Crlc31 nrlc31_2 rlc1 1.46989098614e-13
* RLC[32] P2A-rlc2
Rrlc32 P2A nrlc32_1 1482.72755464
Lrlc32 nrlc32_1 nrlc32_2 1.40396036849e-05
Crlc32 nrlc32_2 rlc2 1.29890434629e-14
* RLC[33] P2A-rlc3
Rrlc33 P2A nrlc33_1 57.8437087271
Lrlc33 nrlc33_1 nrlc33_2 5.27842722807e-07
Crlc33 nrlc33_2 rlc3 1.75287024086e-13
* RLC[35] P2A-rlc5
Rrlc35 P2A nrlc35_1 572.784319188
Lrlc35 nrlc35_1 nrlc35_2 3.97968207051e-06
Crlc35 nrlc35_2 rlc5 1.34779434238e-14
* RLC[36] P2A-rlc6
Rrlc36 P2A nrlc36_1 1.80559213393
Lrlc36 nrlc36_1 nrlc36_2 1.38159636009e-09
Crlc36 nrlc36_2 rlc6 4.70886812692e-13
* RLC[37] P2A-rlc7
Rrlc37 P2A nrlc37_1 18.8590024742
Lrlc37 nrlc37_1 nrlc37_2 1.70331874261e-07
Crlc37 nrlc37_2 rlc7 5.32127839723e-13
* RLC[38] P2A-rlc8
Rrlc38 P2A nrlc38_1 12092.4298767
Lrlc38 nrlc38_1 nrlc38_2 9.11560064173e-05
Crlc38 nrlc38_2 rlc8 2.21771284712e-14
* RLC[39] P2A-rlc9
Rrlc39 P2A nrlc39_1 840.50915482
Lrlc39 nrlc39_1 nrlc39_2 8.05343800958e-06
Crlc39 nrlc39_2 rlc9 2.29032725968e-14
* RLC[40] P2A-rlc10
Rrlc40 P2A nrlc40_1 481618.587577
Lrlc40 nrlc40_1 nrlc40_2 1.21286018165e-09
Crlc40 nrlc40_2 rlc10 5.28709638064e-12
* RLC[43] P2A-rlc13
Rrlc43 P2A nrlc43_1 36.1988941194
Lrlc43 nrlc43_1 nrlc43_2 3.28879581361e-07
Crlc43 nrlc43_2 rlc13 2.78875415405e-13
* RLC[44] P2A-rlc14
Rrlc44 P2A nrlc44_1 10.1303769667
Lrlc44 nrlc44_1 nrlc44_2 9.28999770317e-08
Crlc44 nrlc44_2 rlc14 1.00582374576e-12
* RLC[45] P2A-rlc15
Rrlc45 P2A nrlc45_1 1271018.94231
Lrlc45 nrlc45_1 nrlc45_2 0.00934669487885
Crlc45 nrlc45_2 rlc15 8.8697362323e-08
* RLC[46] P2A-P1B
Rrlc46 P2A nrlc46_1 2.58860824446
Lrlc46 nrlc46_1 nrlc46_2 2.37623690354e-08
Crlc46 nrlc46_2 P1B 3.94016643261e-12
* RLC[49] P3A-P2B
Rrlc49 P3A nrlc49_1 170.222216075
Lrlc49 nrlc49_1 nrlc49_2 1.01267212323e-07
Crlc49 nrlc49_2 P2B 6.01285735397e-14
* RLC[52] P3A-rlc0
Rrlc52 P3A nrlc52_1 552229.268675
Lrlc52 nrlc52_1 nrlc52_2 0.901845199609
Crlc52 nrlc52_2 rlc0 3.61760711718e-12
* RLC[53] P3A-rlc1
Rrlc53 P3A nrlc53_1 97.1931613605
Lrlc53 nrlc53_1 nrlc53_2 5.3438920918e-07
Crlc53 nrlc53_2 rlc1 6.285556775e-14
* RLC[54] P3A-rlc2
Rrlc54 P3A nrlc54_1 518.541413141
Lrlc54 nrlc54_1 nrlc54_2 1.45409030034e-05
Crlc54 nrlc54_2 rlc2 6.00872010226e-14
* RLC[55] P3A-rlc3
Rrlc55 P3A nrlc55_1 1.14320701259
Lrlc55 nrlc55_1 nrlc55_2 1.3890884741e-08
Crlc55 nrlc55_2 rlc3 1.18096666421e-11
* RLC[57] P3A-rlc5
Rrlc57 P3A nrlc57_1 7851766.56604
Lrlc57 nrlc57_1 nrlc57_2 3.21692252854e-07
Crlc57 nrlc57_2 rlc5 5.98951779628e-08
* RLC[58] P3A-rlc6
Rrlc58 P3A nrlc58_1 1738638.23518
Lrlc58 nrlc58_1 nrlc58_2 4.13523265499e-07
Crlc58 nrlc58_2 rlc6 6.70623928301e-12
* RLC[59] P3A-rlc7
Rrlc59 P3A nrlc59_1 12.7362402336
Lrlc59 nrlc59_1 nrlc59_2 3.13458038451e-08
Crlc59 nrlc59_2 rlc7 2.15010497666e-13
* RLC[61] P3A-rlc9
Rrlc61 P3A nrlc61_1 12.90833621
Lrlc61 nrlc61_1 nrlc61_2 4.25281414369e-08
Crlc61 nrlc61_2 rlc9 2.83591596283e-13
* RLC[62] P3A-rlc10
Rrlc62 P3A nrlc62_1 2140.44828937
Lrlc62 nrlc62_1 nrlc62_2 5.23368829099e-06
Crlc62 nrlc62_2 rlc10 1.26927581446e-15
* RLC[63] P3A-rlc11
Rrlc63 P3A nrlc63_1 13.9827743292
Lrlc63 nrlc63_1 nrlc63_2 2.02766628987e-07
Crlc63 nrlc63_2 rlc11 1.15230454408e-12
* RLC[65] P3A-rlc13
Rrlc65 P3A nrlc65_1 291.819498178
Lrlc65 nrlc65_1 nrlc65_2 3.46608257719e-06
Crlc65 nrlc65_2 rlc13 5.06057979357e-14
* RLC[68] P3A-P1B
Rrlc68 P3A nrlc68_1 2421.31452745
Lrlc68 nrlc68_1 nrlc68_2 2.64560484426e-05
Crlc68 nrlc68_2 P1B 5.01395061715e-15
* RLC[69] P4A-P1B
Rrlc69 P4A nrlc69_1 515560.162163
Lrlc69 nrlc69_1 nrlc69_2 3.08345133663e-09
Crlc69 nrlc69_2 P1B 5.67531477352e-12
* RLC[70] P4A-P2B
Rrlc70 P4A nrlc70_1 399.61338535
Lrlc70 nrlc70_1 nrlc70_2 5.62859952758e-07
Crlc70 nrlc70_2 P2B 1.65866875361e-14
* RLC[71] P4A-P3B
Rrlc71 P4A nrlc71_1 2.48644545452
Lrlc71 nrlc71_1 nrlc71_2 3.54345347425e-08
Crlc71 nrlc71_2 P3B 6.3683416195e-12
* RLC[73] P4A-rlc0
Rrlc73 P4A nrlc73_1 30.6811300292
Lrlc73 nrlc73_1 nrlc73_2 1.2482199294e-07
Crlc73 nrlc73_2 rlc0 1.47334990835e-13
* RLC[75] P4A-rlc2
Rrlc75 P4A nrlc75_1 2.80364349896
Lrlc75 nrlc75_1 nrlc75_2 1.44109107926e-08
Crlc75 nrlc75_2 rlc2 2.03705775014e-12
* RLC[77] P4A-rlc4
Rrlc77 P4A nrlc77_1 57397.5092481
Lrlc77 nrlc77_1 nrlc77_2 1
Crlc77 nrlc77_2 rlc4 1.35396747313e-11
* RLC[78] P4A-rlc5
Rrlc78 P4A nrlc78_1 384371.58457
Lrlc78 nrlc78_1 nrlc78_2 0.102207867864
Crlc78 nrlc78_2 rlc5 5.01308735593e-12
* RLC[80] P4A-rlc7
Rrlc80 P4A nrlc80_1 582.098662003
Lrlc80 nrlc80_1 nrlc80_2 2.01202868382e-06
Crlc80 nrlc80_2 rlc7 6.59778951336e-15
* RLC[81] P4A-rlc8
Rrlc81 P4A nrlc81_1 17.9468093675
Lrlc81 nrlc81_1 nrlc81_2 6.7666443915e-08
Crlc81 nrlc81_2 rlc8 2.33429825107e-13
* RLC[83] P4A-rlc10
Rrlc83 P4A nrlc83_1 18768.0281507
Lrlc83 nrlc83_1 nrlc83_2 0.000175779975925
Crlc83 nrlc83_2 rlc10 5.54484740563e-16
* RLC[84] P4A-rlc11
Rrlc84 P4A nrlc84_1 167503.799827
Lrlc84 nrlc84_1 nrlc84_2 0.949827549084
Crlc84 nrlc84_2 rlc11 2.62080256435e-11
* RLC[85] P4A-rlc12
Rrlc85 P4A nrlc85_1 262531.199696
Lrlc85 nrlc85_1 nrlc85_2 0.00524048951314
Crlc85 nrlc85_2 rlc12 1.10720422836e-11
* RLC[87] P4A-rlc14
Rrlc87 P4A nrlc87_1 6561842.78882
Lrlc87 nrlc87_1 nrlc87_2 8.20218159218e-08
Crlc87 nrlc87_2 rlc14 4.03826354407e-07
* RLC[89] P4A-P1B
Rrlc89 P4A nrlc89_1 19.7527295622
Lrlc89 nrlc89_1 nrlc89_2 8.32136962596e-08
Crlc89 nrlc89_2 P1B 2.36972564414e-13
* RLC[90] P1B-P2B
Rrlc90 P1B nrlc90_1 1791.6928361
Lrlc90 nrlc90_1 nrlc90_2 2.51239580739e-05
Crlc90 nrlc90_2 P2B 1.2182078589e-14
* RLC[91] P1B-P3B
Rrlc91 P1B nrlc91_1 24.479490526
Lrlc91 nrlc91_1 nrlc91_2 5.48956553291e-08
Crlc91 nrlc91_2 P3B 1.01786625055e-13
* RLC[92] P1B-P4B
Rrlc92 P1B nrlc92_1 4977.83528488
Lrlc92 nrlc92_1 nrlc92_2 6.14959506736e-06
Crlc92 nrlc92_2 P4B 4.34196743793e-15
* RLC[94] P1B-rlc1
Rrlc94 P1B nrlc94_1 37.2682973419
Lrlc94 nrlc94_1 nrlc94_2 2.8432230578e-06
Crlc94 nrlc94_2 rlc1 1.90186493216e-08
* RLC[97] P1B-rlc4
Rrlc97 P1B nrlc97_1 0.73495642291
Lrlc97 nrlc97_1 nrlc97_2 1.19669945035e-09
Crlc97 nrlc97_2 rlc4 7.90536387283e-12
* RLC[99] P1B-rlc6
Rrlc99 P1B nrlc99_1 99.5110009796
Lrlc99 nrlc99_1 nrlc99_2 2.92983591352e-06
Crlc99 nrlc99_2 rlc6 1.12203480265e-09
* RLC[100] P1B-rlc7
Rrlc100 P1B nrlc100_1 33.2765570846
Lrlc100 nrlc100_1 nrlc100_2 6.0860318496e-07
Crlc100 nrlc100_2 rlc7 1.46576431914e-06
* RLC[101] P1B-rlc8
Rrlc101 P1B nrlc101_1 0.0594466835288
Lrlc101 nrlc101_1 nrlc101_2 0.000121932898757
Crlc101 nrlc101_2 rlc8 3.83374416141e-05
* RLC[102] P1B-rlc9
Rrlc102 P1B nrlc102_1 260.720150646
Lrlc102 nrlc102_1 nrlc102_2 1.62325252142e-06
Crlc102 nrlc102_2 rlc9 3.49952518768e-12
* RLC[103] P1B-rlc10
Rrlc103 P1B nrlc103_1 4489.78215462
Lrlc103 nrlc103_1 nrlc103_2 6.46299499418e-05
Crlc103 nrlc103_2 rlc10 2.39258072482e-11
* RLC[104] P1B-rlc11
Rrlc104 P1B nrlc104_1 1652.50064006
Lrlc104 nrlc104_1 nrlc104_2 7.25217099996e-06
Crlc104 nrlc104_2 rlc11 4.33996869931e-12
* RLC[105] P1B-rlc12
Rrlc105 P1B nrlc105_1 16.5740716589
Lrlc105 nrlc105_1 nrlc105_2 1.50761792631e-07
Crlc105 nrlc105_2 rlc12 6.09804126568e-13
* RLC[106] P1B-rlc13
Rrlc106 P1B nrlc106_1 12.7912366296
Lrlc106 nrlc106_1 nrlc106_2 5.22117180261e-07
Crlc106 nrlc106_2 rlc13 2.30260627556e-08
* RLC[107] P1B-rlc14
Rrlc107 P1B nrlc107_1 0.01
Lrlc107 nrlc107_1 nrlc107_2 5.6500852407e-11
Crlc107 nrlc107_2 rlc14 1.74445016057e-07
* RLC[111] P2B-P4B
Rrlc111 P2B nrlc111_1 569.259689571
Lrlc111 nrlc111_1 nrlc111_2 3.80596607854e-06
Crlc111 nrlc111_2 P4B 2.3472036354e-13
* RLC[112] P2B-rlc0
Rrlc112 P2B nrlc112_1 1328.90701194
Lrlc112 nrlc112_1 nrlc112_2 7.06184924756e-06
Crlc112 nrlc112_2 rlc0 7.82739940959e-14
* RLC[113] P2B-rlc1
Rrlc113 P2B nrlc113_1 10.8117355583
Lrlc113 nrlc113_1 nrlc113_2 2.3324325759e-09
Crlc113 nrlc113_2 rlc1 2.21705168232e-14
* RLC[114] P2B-rlc2
Rrlc114 P2B nrlc114_1 3194.15444157
Lrlc114 nrlc114_1 nrlc114_2 2.8060749069e-05
Crlc114 nrlc114_2 rlc2 0.000157883841089
* RLC[115] P2B-rlc3
Rrlc115 P2B nrlc115_1 322.577363492
Lrlc115 nrlc115_1 nrlc115_2 1.89065467946e-06
Crlc115 nrlc115_2 rlc3 4.36572083169e-12
* RLC[118] P2B-rlc6
Rrlc118 P2B nrlc118_1 68.5867641749
Lrlc118 nrlc118_1 nrlc118_2 7.82555430683e-06
Crlc118 nrlc118_2 rlc6 1.58710094893e-05
* RLC[120] P2B-rlc8
Rrlc120 P2B nrlc120_1 406.287772909
Lrlc120 nrlc120_1 nrlc120_2 1.11501772132e-05
Crlc120 nrlc120_2 rlc8 1.44581046351e-11
* RLC[121] P2B-rlc9
Rrlc121 P2B nrlc121_1 3.46634115925
Lrlc121 nrlc121_1 nrlc121_2 7.00182703129e-09
Crlc121 nrlc121_2 rlc9 6.47479854732e-13
* RLC[122] P2B-rlc10
Rrlc122 P2B nrlc122_1 0.01
Lrlc122 nrlc122_1 nrlc122_2 1.44491940304e-13
Crlc122 nrlc122_2 rlc10 6.85077653217e-12
* RLC[123] P2B-rlc11
Rrlc123 P2B nrlc123_1 843.488602799
Lrlc123 nrlc123_1 nrlc123_2 4.84225026037e-06
Crlc123 nrlc123_2 rlc11 7.56218475071e-15
* RLC[124] P2B-rlc12
Rrlc124 P2B nrlc124_1 4149.0514401
Lrlc124 nrlc124_1 nrlc124_2 1.41551973543e-05
Crlc124 nrlc124_2 rlc12 7.99756631814e-15
* RLC[125] P2B-rlc13
Rrlc125 P2B nrlc125_1 0.63115031697
Lrlc125 nrlc125_1 nrlc125_2 9.60990457107e-07
Crlc125 nrlc125_2 rlc13 0.001
* RLC[126] P2B-rlc14
Rrlc126 P2B nrlc126_1 4.42231520801
Lrlc126 nrlc126_1 nrlc126_2 8.28292276474e-07
Crlc126 nrlc126_2 rlc14 9.13379181172e-07
* RLC[128] P2B-P1B
Rrlc128 P2B nrlc128_1 982.998986122
Lrlc128 nrlc128_1 nrlc128_2 1.8172274868e-05
Crlc128 nrlc128_2 P1B 3.79257758186e-12
* RLC[129] P3B-P4B
Rrlc129 P3B nrlc129_1 21.2319151823
Lrlc129 nrlc129_1 nrlc129_2 3.97682093707e-06
Crlc129 nrlc129_2 P4B 2.34251951988e-08
* RLC[134] P3B-rlc4
Rrlc134 P3B nrlc134_1 450.683255924
Lrlc134 nrlc134_1 nrlc134_2 2.36629164927e-06
Crlc134 nrlc134_2 rlc4 1.07175291243e-12
* RLC[136] P3B-rlc6
Rrlc136 P3B nrlc136_1 1771.62198831
Lrlc136 nrlc136_1 nrlc136_2 6.15979318513e-06
Crlc136 nrlc136_2 rlc6 1.22922877656e-12
* RLC[138] P3B-rlc8
Rrlc138 P3B nrlc138_1 74.9769127465
Lrlc138 nrlc138_1 nrlc138_2 2.57063331993e-06
Crlc138 nrlc138_2 rlc8 5.08092185158e-13
* RLC[139] P3B-rlc9
Rrlc139 P3B nrlc139_1 0.01
Lrlc139 nrlc139_1 nrlc139_2 2.25909457657e-13
Crlc139 nrlc139_2 rlc9 9.84759791838e-12
* RLC[144] P3B-rlc14
Rrlc144 P3B nrlc144_1 514.219083008
Lrlc144 nrlc144_1 nrlc144_2 3.69362349542e-06
Crlc144 nrlc144_2 rlc14 1.58611350373e-06
* RLC[145] P3B-rlc15
Rrlc145 P3B nrlc145_1 1540.76980017
Lrlc145 nrlc145_1 nrlc145_2 7.28672759014e-06
Crlc145 nrlc145_2 rlc15 2.41114475524e-12
* RLC[146] P3B-P1B
Rrlc146 P3B nrlc146_1 6.6812320277
Lrlc146 nrlc146_1 nrlc146_2 6.54464859454e-07
Crlc146 nrlc146_2 P1B 5.16721872535e-08
* RLC[148] P4B-rlc1
Rrlc148 P4B nrlc148_1 0.0104563876711
Lrlc148 nrlc148_1 nrlc148_2 1.15961131096e-09
Crlc148 nrlc148_2 rlc1 1.17843757219e-08
* RLC[149] P4B-rlc2
Rrlc149 P4B nrlc149_1 0.06129578673
Lrlc149 nrlc149_1 nrlc149_2 1.78331957335e-11
Crlc149 nrlc149_2 rlc2 5.27382141916e-12
* RLC[150] P4B-rlc3
Rrlc150 P4B nrlc150_1 1112.01960348
Lrlc150 nrlc150_1 nrlc150_2 1.82849302645e-06
Crlc150 nrlc150_2 rlc3 7.55448431273e-12
* RLC[153] P4B-rlc6
Rrlc153 P4B nrlc153_1 67995.8983756
Lrlc153 nrlc153_1 nrlc153_2 1.47136757139e-06
Crlc153 nrlc153_2 rlc6 5.18950132932e-15
* RLC[157] P4B-rlc10
Rrlc157 P4B nrlc157_1 1196.14427823
Lrlc157 nrlc157_1 nrlc157_2 1.77011249217e-06
Crlc157 nrlc157_2 rlc10 1.14443675301e-12
* RLC[159] P4B-rlc12
Rrlc159 P4B nrlc159_1 736.129056135
Lrlc159 nrlc159_1 nrlc159_2 6.41276793966e-06
Crlc159 nrlc159_2 rlc12 1.31490717197e-14
* RLC[160] P4B-rlc13
Rrlc160 P4B nrlc160_1 230.982280831
Lrlc160 nrlc160_1 nrlc160_2 5.79302020102e-05
Crlc160 nrlc160_2 rlc13 3.80946125981e-09
* RLC[164] rlc0-rlc1
Rrlc164 rlc0 nrlc164_1 449.839550031
Lrlc164 nrlc164_1 nrlc164_2 8.63191357812e-07
Crlc164 nrlc164_2 rlc1 3.22790312294e-12
* RLC[166] rlc0-rlc3
Rrlc166 rlc0 nrlc166_1 142366.479644
Lrlc166 nrlc166_1 nrlc166_2 0.0370132401141
Crlc166 nrlc166_2 rlc3 4.49650678778e-11
* RLC[167] rlc0-rlc4
Rrlc167 rlc0 nrlc167_1 1.54212177125
Lrlc167 nrlc167_1 nrlc167_2 1.65878424762e-08
Crlc167 nrlc167_2 rlc4 7.75014907242e-12
* RLC[168] rlc0-rlc5
Rrlc168 rlc0 nrlc168_1 9.56158582928
Lrlc168 nrlc168_1 nrlc168_2 1.2097056063e-09
Crlc168 nrlc168_2 rlc5 3.90093439441e-13
* RLC[169] rlc0-rlc6
Rrlc169 rlc0 nrlc169_1 1.32980338064
Lrlc169 nrlc169_1 nrlc169_2 2.31854852844e-08
Crlc169 nrlc169_2 rlc6 1.45679625228e-11
* RLC[171] rlc0-rlc8
Rrlc171 rlc0 nrlc171_1 226.162055318
Lrlc171 nrlc171_1 nrlc171_2 1.3983211814e-07
Crlc171 nrlc171_2 rlc8 0.000106668120022
* RLC[173] rlc0-rlc10
Rrlc173 rlc0 nrlc173_1 4015.55363523
Lrlc173 nrlc173_1 nrlc173_2 1.19548667612e-06
Crlc173 nrlc173_2 rlc10 5.63960356233e-10
* RLC[175] rlc0-rlc12
Rrlc175 rlc0 nrlc175_1 2.72270706529
Lrlc175 nrlc175_1 nrlc175_2 5.14831787796e-09
Crlc175 nrlc175_2 rlc12 1.23854216453e-11
* RLC[176] rlc0-rlc13
Rrlc176 rlc0 nrlc176_1 115.322711772
Lrlc176 nrlc176_1 nrlc176_2 8.88472308002e-07
Crlc176 nrlc176_2 rlc13 8.77466074394e-11
* RLC[177] rlc0-rlc14
Rrlc177 rlc0 nrlc177_1 0.01
Lrlc177 nrlc177_1 nrlc177_2 4.24004702789e-08
Crlc177 nrlc177_2 rlc14 0.001
* RLC[178] rlc0-rlc15
Rrlc178 rlc0 nrlc178_1 5.81111176501
Lrlc178 nrlc178_1 nrlc178_2 5.21403960219e-08
Crlc178 nrlc178_2 rlc15 1.71558942046e-12
* RLC[180] rlc1-rlc2
Rrlc180 rlc1 nrlc180_1 0.333739387646
Lrlc180 nrlc180_1 nrlc180_2 7.81573878861e-09
Crlc180 nrlc180_2 rlc2 7.79673183936e-11
* RLC[181] rlc1-rlc3
Rrlc181 rlc1 nrlc181_1 71.7068548872
Lrlc181 nrlc181_1 nrlc181_2 2.4004691819e-07
Crlc181 nrlc181_2 rlc3 9.96950842154e-12
* RLC[184] rlc1-rlc6
Rrlc184 rlc1 nrlc184_1 246.023154664
Lrlc184 nrlc184_1 nrlc184_2 3.99039405229e-06
Crlc184 nrlc184_2 rlc6 7.32523073688e-14
* RLC[186] rlc1-rlc8
Rrlc186 rlc1 nrlc186_1 45.3462239582
Lrlc186 nrlc186_1 nrlc186_2 3.85279590502e-07
Crlc186 nrlc186_2 rlc8 2.08185863897e-13
* RLC[188] rlc1-rlc10
Rrlc188 rlc1 nrlc188_1 7.02680060577
Lrlc188 nrlc188_1 nrlc188_2 1.5554647714e-08
Crlc188 nrlc188_2 rlc10 3.50027751793e-13
* RLC[189] rlc1-rlc11
Rrlc189 rlc1 nrlc189_1 2.81684772698
Lrlc189 nrlc189_1 nrlc189_2 3.8461654638e-08
Crlc189 nrlc189_2 rlc11 5.38590530422e-12
* RLC[190] rlc1-rlc12
Rrlc190 rlc1 nrlc190_1 887.213278241
Lrlc190 nrlc190_1 nrlc190_2 1.01700272373e-05
Crlc190 nrlc190_2 rlc12 1.20332672664e-09
* RLC[194] rlc1-P1B
Rrlc194 rlc1 nrlc194_1 2.16710745763
Lrlc194 nrlc194_1 nrlc194_2 1.7568757683e-08
Crlc194 nrlc194_2 P1B 4.15659441849e-12
* RLC[195] rlc2-rlc3
Rrlc195 rlc2 nrlc195_1 0.552369939394
Lrlc195 nrlc195_1 nrlc195_2 9.26523840378e-09
Crlc195 nrlc195_2 rlc3 3.37406945055e-11
* RLC[196] rlc2-rlc4
Rrlc196 rlc2 nrlc196_1 2188.3916059
Lrlc196 nrlc196_1 nrlc196_2 2.96314275193e-05
Crlc196 nrlc196_2 rlc4 8.71873970087e-14
* RLC[198] rlc2-rlc6
Rrlc198 rlc2 nrlc198_1 83.6540214896
Lrlc198 nrlc198_1 nrlc198_2 2.28183916336e-06
Crlc198 nrlc198_2 rlc6 3.62300449681e-13
* RLC[200] rlc2-rlc8
Rrlc200 rlc2 nrlc200_1 160.326120079
Lrlc200 nrlc200_1 nrlc200_2 1.02994635931e-06
Crlc200 nrlc200_2 rlc8 4.45208586714e-14
* RLC[201] rlc2-rlc9
Rrlc201 rlc2 nrlc201_1 9691.19798434
Lrlc201 nrlc201_1 nrlc201_2 0.000286344632405
Crlc201 nrlc201_2 rlc9 1.33323813565e-06
* RLC[202] rlc2-rlc10
Rrlc202 rlc2 nrlc202_1 2036.02409229
Lrlc202 nrlc202_1 nrlc202_2 0.00150643219664
Crlc202 nrlc202_2 rlc10 2.83126264834e-07
* RLC[203] rlc2-rlc11
Rrlc203 rlc2 nrlc203_1 15.5514316962
Lrlc203 nrlc203_1 nrlc203_2 5.04364280666e-07
Crlc203 nrlc203_2 rlc11 2.31718686556e-12
* RLC[204] rlc2-rlc12
Rrlc204 rlc2 nrlc204_1 413.458545489
Lrlc204 nrlc204_1 nrlc204_2 8.59376542005e-06
Crlc204 nrlc204_2 rlc12 5.58569271657e-14
* RLC[205] rlc2-rlc13
Rrlc205 rlc2 nrlc205_1 0.0268224640762
Lrlc205 nrlc205_1 nrlc205_2 3.06739228376e-12
Crlc205 nrlc205_2 rlc13 4.73728449355e-12
* RLC[206] rlc2-rlc14
Rrlc206 rlc2 nrlc206_1 15884.7235794
Lrlc206 nrlc206_1 nrlc206_2 0.0198440520236
Crlc206 nrlc206_2 rlc14 7.01875583256e-11
* RLC[207] rlc2-rlc15
Rrlc207 rlc2 nrlc207_1 1565.71224829
Lrlc207 nrlc207_1 nrlc207_2 7.09695049238e-06
Crlc207 nrlc207_2 rlc15 1.69637215155e-12
* RLC[208] rlc2-P1B
Rrlc208 rlc2 nrlc208_1 4594.03290082
Lrlc208 nrlc208_1 nrlc208_2 7.10049532627e-05
Crlc208 nrlc208_2 P1B 1.55526460242e-12
* RLC[211] rlc3-rlc6
Rrlc211 rlc3 nrlc211_1 2206.24088227
Lrlc211 nrlc211_1 nrlc211_2 2.15664533785e-05
Crlc211 nrlc211_2 rlc6 4.92300600579e-15
* RLC[213] rlc3-rlc8
Rrlc213 rlc3 nrlc213_1 1534.03153813
Lrlc213 nrlc213_1 nrlc213_2 1.88573069456e-05
Crlc213 nrlc213_2 rlc8 8.90668386305e-15
* RLC[215] rlc3-rlc10
Rrlc215 rlc3 nrlc215_1 5374.81721056
Lrlc215 nrlc215_1 nrlc215_2 5.20064887387e-05
Crlc215 nrlc215_2 rlc10 1.04193968712e-13
* RLC[216] rlc3-rlc11
Rrlc216 rlc3 nrlc216_1 69565.7533065
Lrlc216 nrlc216_1 nrlc216_2 0.00094149288446
Crlc216 nrlc216_2 rlc11 3.93995725097e-12
* RLC[218] rlc3-rlc13
Rrlc218 rlc3 nrlc218_1 1110.96358361
Lrlc218 nrlc218_1 nrlc218_2 0.239820042512
Crlc218 nrlc218_2 rlc13 6.00324671061e-06
* RLC[219] rlc3-rlc14
Rrlc219 rlc3 nrlc219_1 2353.8093562
Lrlc219 nrlc219_1 nrlc219_2 8.15608938067e-05
Crlc219 nrlc219_2 rlc14 1.63567455384e-14
* RLC[220] rlc3-rlc15
Rrlc220 rlc3 nrlc220_1 0.134726807083
Lrlc220 nrlc220_1 nrlc220_2 3.9742782328e-11
Crlc220 nrlc220_2 rlc15 2.43280737506e-12
* RLC[222] rlc4-rlc5
Rrlc222 rlc4 nrlc222_1 90.1312262382
Lrlc222 nrlc222_1 nrlc222_2 1.73923384447e-06
Crlc222 nrlc222_2 rlc5 2.96317012561e-13
* RLC[224] rlc4-rlc7
Rrlc224 rlc4 nrlc224_1 513.735429386
Lrlc224 nrlc224_1 nrlc224_2 0.000238134872531
Crlc224 nrlc224_2 rlc7 0.000112500429996
* RLC[225] rlc4-rlc8
Rrlc225 rlc4 nrlc225_1 5.85426669078
Lrlc225 nrlc225_1 nrlc225_2 4.19688177604e-08
Crlc225 nrlc225_2 rlc8 2.41859272982e-12
* RLC[226] rlc4-rlc9
Rrlc226 rlc4 nrlc226_1 4.76723631958
Lrlc226 nrlc226_1 nrlc226_2 3.46355654618e-08
Crlc226 nrlc226_2 rlc9 1.69334874657e-12
* RLC[229] rlc4-rlc12
Rrlc229 rlc4 nrlc229_1 3.27565834177
Lrlc229 nrlc229_1 nrlc229_2 3.74166397842e-08
Crlc229 nrlc229_2 rlc12 3.87458397829e-12
* RLC[230] rlc4-rlc13
Rrlc230 rlc4 nrlc230_1 5.34283176111
Lrlc230 nrlc230_1 nrlc230_2 5.6010721934e-08
Crlc230 nrlc230_2 rlc13 2.1801464243e-12
* RLC[231] rlc4-rlc14
Rrlc231 rlc4 nrlc231_1 4.73261068352
Lrlc231 nrlc231_1 nrlc231_2 3.83443871955e-08
Crlc231 nrlc231_2 rlc14 1.90220681134e-12
* RLC[233] rlc4-P1B
Rrlc233 rlc4 nrlc233_1 35.1266745017
Lrlc233 nrlc233_1 nrlc233_2 1.13385507029e-06
Crlc233 nrlc233_2 P1B 1.35955494945e-11
* RLC[235] rlc5-rlc7
Rrlc235 rlc5 nrlc235_1 5.11468668618
Lrlc235 nrlc235_1 nrlc235_2 6.99985297409e-08
Crlc235 nrlc235_2 rlc7 1.78042701427e-10
* RLC[237] rlc5-rlc9
Rrlc237 rlc5 nrlc237_1 1014.90596059
Lrlc237 nrlc237_1 nrlc237_2 5.04697823983e-05
Crlc237 nrlc237_2 rlc9 2.82804874503e-09
* RLC[239] rlc5-rlc11
Rrlc239 rlc5 nrlc239_1 23.8977309451
Lrlc239 nrlc239_1 nrlc239_2 0.00338873903054
Crlc239 nrlc239_2 rlc11 2.6399606495e-05
* RLC[241] rlc5-rlc13
Rrlc241 rlc5 nrlc241_1 0.01
Lrlc241 nrlc241_1 nrlc241_2 3.58224984709e-08
Crlc241 nrlc241_2 rlc13 0.001
* RLC[242] rlc5-rlc14
Rrlc242 rlc5 nrlc242_1 3.51717856709
Lrlc242 nrlc242_1 nrlc242_2 8.83616506865e-08
Crlc242 nrlc242_2 rlc14 1.01252500135e-11
* RLC[243] rlc5-rlc15
Rrlc243 rlc5 nrlc243_1 2.00159383615
Lrlc243 nrlc243_1 nrlc243_2 5.69795914138e-08
Crlc243 nrlc243_2 rlc15 1.58024677015e-11
* RLC[244] rlc5-P1B
Rrlc244 rlc5 nrlc244_1 29.3257524943
Lrlc244 nrlc244_1 nrlc244_2 2.66038391655e-07
Crlc244 nrlc244_2 P1B 1.55317179724e-08
* RLC[245] rlc6-rlc7
Rrlc245 rlc6 nrlc245_1 75.5234231513
Lrlc245 nrlc245_1 nrlc245_2 1.12276683004e-06
Crlc245 nrlc245_2 rlc7 2.18717599873e-13
* RLC[246] rlc6-rlc8
Rrlc246 rlc6 nrlc246_1 92.3198045376
Lrlc246 nrlc246_1 nrlc246_2 3.96389067032e-07
Crlc246 nrlc246_2 rlc8 5.82121546688e-11
* RLC[247] rlc6-rlc9
Rrlc247 rlc6 nrlc247_1 1139.21072692
Lrlc247 nrlc247_1 nrlc247_2 6.35991756569e-06
Crlc247 nrlc247_2 rlc9 4.00920034587e-12
* RLC[252] rlc6-rlc14
Rrlc252 rlc6 nrlc252_1 1495.6462444
Lrlc252 nrlc252_1 nrlc252_2 1.15172398669e-05
Crlc252 nrlc252_2 rlc14 5.72068629273e-15
* RLC[254] rlc6-P1B
Rrlc254 rlc6 nrlc254_1 27.9391833421
Lrlc254 nrlc254_1 nrlc254_2 1.92442114122e-06
Crlc254 nrlc254_2 P1B 3.31514673638e-09
* RLC[255] rlc7-rlc8
Rrlc255 rlc7 nrlc255_1 9.19908500406
Lrlc255 nrlc255_1 nrlc255_2 1.19168684801e-07
Crlc255 nrlc255_2 rlc8 1.56469744327e-12
* RLC[256] rlc7-rlc9
Rrlc256 rlc7 nrlc256_1 24.0689467443
Lrlc256 nrlc256_1 nrlc256_2 1.13986400017e-07
Crlc256 nrlc256_2 rlc9 6.49881816562e-13
* RLC[258] rlc7-rlc11
Rrlc258 rlc7 nrlc258_1 1759.47154511
Lrlc258 nrlc258_1 nrlc258_2 1.53086756855e-05
Crlc258 nrlc258_2 rlc11 1.66068754904e-13
* RLC[260] rlc7-rlc13
Rrlc260 rlc7 nrlc260_1 7.3536278145
Lrlc260 nrlc260_1 nrlc260_2 4.47581411613e-07
Crlc260 nrlc260_2 rlc13 3.42972813554e-11
* RLC[261] rlc7-rlc14
Rrlc261 rlc7 nrlc261_1 273.559230185
Lrlc261 nrlc261_1 nrlc261_2 6.2797915433e-06
Crlc261 nrlc261_2 rlc14 9.32395078167e-14
* RLC[262] rlc7-rlc15
Rrlc262 rlc7 nrlc262_1 2.37743297735
Lrlc262 nrlc262_1 nrlc262_2 2.45936995755e-08
Crlc262 nrlc262_2 rlc15 1.01789276356e-11
* RLC[263] rlc7-P1B
Rrlc263 rlc7 nrlc263_1 449.276530937
Lrlc263 nrlc263_1 nrlc263_2 1.67693733304e-05
Crlc263 nrlc263_2 P1B 9.23095977414e-14
* RLC[264] rlc8-rlc9
Rrlc264 rlc8 nrlc264_1 689.662433287
Lrlc264 nrlc264_1 nrlc264_2 7.03448832026e-06
Crlc264 nrlc264_2 rlc9 1.66023052417e-12
* RLC[266] rlc8-rlc11
Rrlc266 rlc8 nrlc266_1 7.74286557835
Lrlc266 nrlc266_1 nrlc266_2 5.56316317904e-08
Crlc266 nrlc266_2 rlc11 1.03104079697e-12
* RLC[268] rlc8-rlc13
Rrlc268 rlc8 nrlc268_1 16.5141791593
Lrlc268 nrlc268_1 nrlc268_2 1.95738001579e-07
Crlc268 nrlc268_2 rlc13 7.97477900475e-13
* RLC[269] rlc8-rlc14
Rrlc269 rlc8 nrlc269_1 3023.61086948
Lrlc269 nrlc269_1 nrlc269_2 2.73592244018e-05
Crlc269 nrlc269_2 rlc14 3.32513648539e-15
* RLC[270] rlc8-rlc15
Rrlc270 rlc8 nrlc270_1 23.4813356957
Lrlc270 nrlc270_1 nrlc270_2 1.95221076123e-08
Crlc270 nrlc270_2 rlc15 2.98772151959e-13
* RLC[271] rlc8-P1B
Rrlc271 rlc8 nrlc271_1 0.127608071785
Lrlc271 nrlc271_1 nrlc271_2 1.18881724961e-05
Crlc271 nrlc271_2 P1B 8.18851463463e-07
* RLC[272] rlc9-rlc10
Rrlc272 rlc9 nrlc272_1 38.5922209873
Lrlc272 nrlc272_1 nrlc272_2 0.000225831239839
Crlc272 nrlc272_2 rlc10 2.36604440214e-08
* RLC[273] rlc9-rlc11
Rrlc273 rlc9 nrlc273_1 1481.69673604
Lrlc273 nrlc273_1 nrlc273_2 0.00458114463328
Crlc273 nrlc273_2 rlc11 1.55697151979e-08
* RLC[274] rlc9-rlc12
Rrlc274 rlc9 nrlc274_1 2.48159582882
Lrlc274 nrlc274_1 nrlc274_2 1.93229137038e-08
Crlc274 nrlc274_2 rlc12 3.4863260734e-12
* RLC[275] rlc9-rlc13
Rrlc275 rlc9 nrlc275_1 0.01
Lrlc275 nrlc275_1 nrlc275_2 2.81217875252e-13
Crlc275 nrlc275_2 rlc13 1.34452628792e-10
* RLC[276] rlc9-rlc14
Rrlc276 rlc9 nrlc276_1 5621.80827677
Lrlc276 nrlc276_1 nrlc276_2 0.00119895230018
Crlc276 nrlc276_2 rlc14 1.3859785173e-10
* RLC[277] rlc9-rlc15
Rrlc277 rlc9 nrlc277_1 8.57797923657
Lrlc277 nrlc277_1 nrlc277_2 2.03256934278e-08
Crlc277 nrlc277_2 rlc15 3.0692543501e-13
* RLC[278] rlc9-P1B
Rrlc278 rlc9 nrlc278_1 167.504349101
Lrlc278 nrlc278_1 nrlc278_2 1.01221794946e-06
Crlc278 nrlc278_2 P1B 3.40977000468e-12
* RLC[279] rlc10-rlc11
Rrlc279 rlc10 nrlc279_1 82.2667570983
Lrlc279 nrlc279_1 nrlc279_2 0.000667183234185
Crlc279 nrlc279_2 rlc11 1.93556766649e-07
* RLC[280] rlc10-rlc12
Rrlc280 rlc10 nrlc280_1 32.3680264981
Lrlc280 nrlc280_1 nrlc280_2 9.07463167932e-07
Crlc280 nrlc280_2 rlc12 9.62396545798e-13
* RLC[282] rlc10-rlc14
Rrlc282 rlc10 nrlc282_1 0.222755359676
Lrlc282 nrlc282_1 nrlc282_2 2.51827723792e-10
Crlc282 nrlc282_2 rlc14 5.63903390676e-12
* RLC[283] rlc10-rlc15
Rrlc283 rlc10 nrlc283_1 362.569652889
Lrlc283 nrlc283_1 nrlc283_2 8.04832748011e-06
Crlc283 nrlc283_2 rlc15 6.80268291403e-14
* RLC[285] rlc11-rlc12
Rrlc285 rlc11 nrlc285_1 2715.41236676
Lrlc285 nrlc285_1 nrlc285_2 4.54297237931e-05
Crlc285 nrlc285_2 rlc12 1.1801088369e-10
* RLC[286] rlc11-rlc13
Rrlc286 rlc11 nrlc286_1 0.587898499274
Lrlc286 nrlc286_1 nrlc286_2 0.00149757960578
Crlc286 nrlc286_2 rlc13 0.000212640365122
* RLC[287] rlc11-rlc14
Rrlc287 rlc11 nrlc287_1 169.683895669
Lrlc287 nrlc287_1 nrlc287_2 3.21192276639e-07
Crlc287 nrlc287_2 rlc14 1.38202673034e-13
* RLC[288] rlc11-rlc15
Rrlc288 rlc11 nrlc288_1 9.30065494368
Lrlc288 nrlc288_1 nrlc288_2 6.49718333833e-08
Crlc288 nrlc288_2 rlc15 8.34556123256e-13
* RLC[290] rlc12-rlc13
Rrlc290 rlc12 nrlc290_1 243.715535708
Lrlc290 nrlc290_1 nrlc290_2 1.86221592418e-07
Crlc290 nrlc290_2 rlc13 1.65400032897e-06
* RLC[291] rlc12-rlc14
Rrlc291 rlc12 nrlc291_1 0.558865695844
Lrlc291 nrlc291_1 nrlc291_2 2.79930950386e-09
Crlc291 nrlc291_2 rlc14 9.95849028019e-12
* RLC[292] rlc12-rlc15
Rrlc292 rlc12 nrlc292_1 78.5919736773
Lrlc292 nrlc292_1 nrlc292_2 8.37066990996e-07
Crlc292 nrlc292_2 rlc15 2.57942103324e-12
* RLC[293] rlc12-P1B
Rrlc293 rlc12 nrlc293_1 0.219186878256
Lrlc293 nrlc293_1 nrlc293_2 1.12119422236e-07
Crlc293 nrlc293_2 P1B 2.59304013647e-09
* RLC[294] rlc13-rlc14
Rrlc294 rlc13 nrlc294_1 6.08296374041
Lrlc294 nrlc294_1 nrlc294_2 4.88455063537e-09
Crlc294 nrlc294_2 rlc14 1.47793637576e-12
* RLC[295] rlc13-rlc15
Rrlc295 rlc13 nrlc295_1 0.22480086263
Lrlc295 nrlc295_1 nrlc295_2 5.56463587834e-10
Crlc295 nrlc295_2 rlc15 1.22348400282e-11
* RLC[296] rlc13-P1B
Rrlc296 rlc13 nrlc296_1 1.02908965963
Lrlc296 nrlc296_1 nrlc296_2 7.35662383693e-09
Crlc296 nrlc296_2 P1B 7.71844140939e-12
* RLC[297] rlc14-rlc15
Rrlc297 rlc14 nrlc297_1 754.751921445
Lrlc297 nrlc297_1 nrlc297_2 2.95686948852e-05
Crlc297 nrlc297_2 rlc15 8.38116581853e-10
* RLC[299] rlc15-P1B
Rrlc299 rlc15 nrlc299_1 7.82238495226
Lrlc299 nrlc299_1 nrlc299_2 2.07790633019e-07
Crlc299 nrlc299_2 P1B 3.77315883565e-12
* DC[0] P1A-P2A
Rdc0 P1A ndc0_1 0.0110757867198
Ldc0 ndc0_1 P2A 5.19736453046e-08
* DC[23] P3A-P4A
Rdc23 P3A ndc23_1 0.01
Ldc23 ndc23_1 P4A 7.37366406151e-08
* DC[42] P1B-P2B
Rdc42 P1B ndc42_1 0.336013732213
Ldc42 ndc42_1 P2B 1.01861787061e-07
* DC[43] P1B-P3B
Rdc43 P1B ndc43_1 29.1909698395
Ldc43 ndc43_1 P3B 4.82643241192e-06
* DC[45] P1B-dc0
Rdc45 P1B ndc45_1 1.78815314626
Ldc45 ndc45_1 dc0 4.06969860885e-07
* DC[47] P1B-dc2
Rdc47 P1B ndc47_1 12.9887055984
Ldc47 ndc47_1 dc2 2.2158671189e-06
* DC[48] P1B-dc3
Rdc48 P1B ndc48_1 130.708804878
Ldc48 ndc48_1 dc3 3.91289623919e-05
* DC[51] P2B-P4B
Rdc51 P2B ndc51_1 4.25947112793
Ldc51 ndc51_1 P4B 7.59656850305e-07
* DC[52] P2B-dc0
Rdc52 P2B ndc52_1 0.113190918308
Ldc52 ndc52_1 dc0 1.02521012842e-07
* DC[54] P2B-dc2
Rdc54 P2B ndc54_1 0.0466807477339
Ldc54 ndc54_1 dc2 1.62717139174e-06
* DC[55] P2B-dc3
Rdc55 P2B ndc55_1 4.79260997753
Ldc55 ndc55_1 dc3 1.32149596381e-06
* DC[56] P2B-P1B
Rdc56 P2B ndc56_1 0.26910284102
Ldc56 ndc56_1 P1B 8.15779049001e-08
* DC[57] P3B-P4B
Rdc57 P3B ndc57_1 13.5797308825
Ldc57 ndc57_1 P4B 3.62682666897e-06
* DC[59] P3B-dc1
Rdc59 P3B ndc59_1 0.0930484711498
Ldc59 ndc59_1 dc1 2.20627518972e-08
* DC[62] P3B-P1B
Rdc62 P3B ndc62_1 27.4784257532
Ldc62 ndc62_1 P1B 4.54328041699e-06
* DC[64] P4B-dc1
Rdc64 P4B ndc64_1 0.114509667517
Ldc64 ndc64_1 dc1 3.33711281474e-08
* DC[71] dc0-P1B
Rdc71 dc0 ndc71_1 1.78032087106
Ldc71 ndc71_1 P1B 4.0518729805e-07
* DC[75] dc2-dc3
Rdc75 dc2 ndc75_1 0.858829193018
Ldc75 ndc75_1 dc3 3.22185203749e-05
* ---- leaks
Rleak_P1A P1A P1B 1e+12
Rleak_P2A P2A P1B 1e+12
Rleak_P2B P2B P1B 1e+12
Rleak_P3A P3A P1B 1e+12
Rleak_P3B P3B P1B 1e+12
Rleak_P4A P4A P1B 1e+12
Rleak_P4B P4B P1B 1e+12
Rleak_dc0 dc0 P1B 1e+12
Rleak_dc1 dc1 P1B 1e+12
Rleak_dc2 dc2 P1B 1e+12
Rleak_dc3 dc3 P1B 1e+12
Rleak_rlc0 rlc0 P1B 1e+12
Rleak_rlc1 rlc1 P1B 1e+12
Rleak_rlc10 rlc10 P1B 1e+12
Rleak_rlc11 rlc11 P1B 1e+12
Rleak_rlc12 rlc12 P1B 1e+12
Rleak_rlc13 rlc13 P1B 1e+12
Rleak_rlc14 rlc14 P1B 1e+12
Rleak_rlc15 rlc15 P1B 1e+12
Rleak_rlc2 rlc2 P1B 1e+12
Rleak_rlc3 rlc3 P1B 1e+12
Rleak_rlc4 rlc4 P1B 1e+12
Rleak_rlc5 rlc5 P1B 1e+12
Rleak_rlc6 rlc6 P1B 1e+12
Rleak_rlc7 rlc7 P1B 1e+12
Rleak_rlc8 rlc8 P1B 1e+12
Rleak_rlc9 rlc9 P1B 1e+12
.ends fitted
