* fitted: 4-port fitted model, reference z0 = 50 Ohm
* port p is PpA (+) to PpB (-); the reference node is P1B
.subckt fitted P1A P1B P2A P2B P3A P3B P4A P4B
* ---- branches
* RLC[1] P1A-P3A
Rrlc1 P1A nrlc1_1 147.492966755
Lrlc1 nrlc1_1 nrlc1_2 3.79727365453e-07
Crlc1 nrlc1_2 P3A 1.93948651352e-14
* RLC[2] P1A-P4A
Rrlc2 P1A nrlc2_1 1243.50636757
Lrlc2 nrlc2_1 nrlc2_2 2.04025013671e-07
Crlc2 nrlc2_2 P4A 1.58576638415e-14
* RLC[4] P1A-P2B
Rrlc4 P1A nrlc4_1 2.62649321376
Lrlc4 nrlc4_1 nrlc4_2 2.84218124419e-08
Crlc4 nrlc4_2 P2B 4.57779872318e-12
* RLC[5] P1A-P3B
Rrlc5 P1A nrlc5_1 16000.6983064
Lrlc5 nrlc5_1 nrlc5_2 2.92477322947e-05
Crlc5 nrlc5_2 P3B 2.92007632256e-15
* RLC[6] P1A-P4B
Rrlc6 P1A nrlc6_1 6180.98088908
Lrlc6 nrlc6_1 nrlc6_2 3.20322915016e-05
Crlc6 nrlc6_2 P4B 2.09410524484e-14
* RLC[8] P1A-rlc1
Rrlc8 P1A nrlc8_1 12.3386123302
Lrlc8 nrlc8_1 nrlc8_2 2.36152584685e-08
Crlc8 nrlc8_2 rlc1 3.42354070393e-13
* RLC[9] P1A-rlc2
Rrlc9 P1A nrlc9_1 3347.55092892
Lrlc9 nrlc9_1 nrlc9_2 0.000116519737986
Crlc9 nrlc9_2 rlc2 1.15532083096e-14
* RLC[10] P1A-rlc3
Rrlc10 P1A nrlc10_1 134413.299723
Lrlc10 nrlc10_1 nrlc10_2 0.963478770837
Crlc10 nrlc10_2 rlc3 1.3386591993e-06
* RLC[11] P1A-rlc4
Rrlc11 P1A nrlc11_1 3797.25049146
Lrlc11 nrlc11_1 nrlc11_2 0.000117674629297
Crlc11 nrlc11_2 rlc4 9.06779796855e-15
* RLC[12] P1A-rlc5
Rrlc12 P1A nrlc12_1 3790095.00833
Lrlc12 nrlc12_1 nrlc12_2 1.0209232191e-05
Crlc12 nrlc12_2 rlc5 2.08721966544e-08
* RLC[15] P1A-rlc8
Rrlc15 P1A nrlc15_1 236306.840856
Lrlc15 nrlc15_1 nrlc15_2 1.81347522231e-08
Crlc15 nrlc15_2 rlc8 2.2080715831e-12
* RLC[16] P1A-rlc9
Rrlc16 P1A nrlc16_1 5229306.17529
Lrlc16 nrlc16_1 nrlc16_2 4.84311005717e-08
Crlc16 nrlc16_2 rlc9 7.29312679975e-13
* RLC[17] P1A-rlc10
Rrlc17 P1A nrlc17_1 588749.741741
Lrlc17 nrlc17_1 nrlc17_2 9.95424814914e-08
Crlc17 nrlc17_2 rlc10 1.81386213602e-12
* RLC[18] P1A-rlc11
Rrlc18 P1A nrlc18_1 744.615067703
Lrlc18 nrlc18_1 nrlc18_2 1.63947215488e-05
Crlc18 nrlc18_2 rlc11 3.28547294438e-14
* RLC[19] P1A-rlc12
Rrlc19 P1A nrlc19_1 2.43990304063
Lrlc19 nrlc19_1 nrlc19_2 5.15631065005e-09
Crlc19 nrlc19_2 rlc12 9.62390723769e-13
* RLC[20] P1A-rlc13
Rrlc20 P1A nrlc20_1 12260.2106499
Lrlc20 nrlc20_1 nrlc20_2 7.81753511218e-05
Crlc20 nrlc20_2 rlc13 6.68860729392e-14
* RLC[21] P1A-rlc14
Rrlc21 P1A nrlc21_1 404768.865144
Lrlc21 nrlc21_1 nrlc21_2 0.683072012862
Crlc21 nrlc21_2 rlc14 1.56391053382e-11
* RLC[26] P2A-P1B
Rrlc26 P2A nrlc26_1 1.28514633116
Lrlc26 nrlc26_1 nrlc26_2 8.22424078693e-14
Crlc26 nrlc26_2 P1B 8.83253566389e-13
* RLC[27] P2A-P2B
Rrlc27 P2A nrlc27_1 269.099837746
Lrlc27 nrlc27_1 nrlc27_2 3.91147061403e-06
Crlc27 nrlc27_2 P2B 6.00165035436e-14
* RLC[29] P2A-P4B
Rrlc29 P2A nrlc29_1 610571.003377
Lrlc29 nrlc29_1 nrlc29_2 0.238230964312
Crlc29 nrlc29_2 P4B 3.21148631234e-12
* RLC[30] P2A-rlc0
Rrlc30 P2A nrlc30_1 709.318863611
Lrlc30 nrlc30_1 nrlc30_2 6.65147761883e-08
Crlc30 nrlc30_2 rlc0 4.72440111912e-14
* RLC[31] P2A-rlc1
Rrlc31 P2A nrlc31_1 966.40719701
Lrlc31 nrlc31_1 nrlc31_2 1.08388435359e-05
Crlc31 nrlc31_2 rlc1 1.28949637774e-14
* RLC[32] P2A-rlc2
Rrlc32 P2A nrlc32_1 1128820.68721
Lrlc32 nrlc32_1 nrlc32_2 1
Crlc32 nrlc32_2 rlc2 3.34698893282e-12
* RLC[38] P2A-rlc8
Rrlc38 P2A nrlc38_1 71.0951287813
Lrlc38 nrlc38_1 nrlc38_2 6.41888644018e-07
Crlc38 nrlc38_2 rlc8 1.41103404538e-13
* RLC[39] P2A-rlc9
Rrlc39 P2A nrlc39_1 854.790219067
Lrlc39 nrlc39_1 nrlc39_2 7.49534467541e-06
Crlc39 nrlc39_2 rlc9 1.13980356536e-14
* RLC[40] P2A-rlc10
Rrlc40 P2A nrlc40_1 987254.75707
Lrlc40 nrlc40_1 nrlc40_2 0.558571851266
Crlc40 nrlc40_2 rlc10 3.47569484117e-12
* RLC[43] P2A-rlc13
Rrlc43 P2A nrlc43_1 1.78702383314
Lrlc43 nrlc43_1 nrlc43_2 1.60331391203e-08
Crlc43 nrlc43_2 rlc13 5.57847334492e-12
* RLC[44] P2A-rlc14
Rrlc44 P2A nrlc44_1 75241.5388418
Lrlc44 nrlc44_1 nrlc44_2 0.000601751420582
Crlc44 nrlc44_2 rlc14 1.6027260723e-13
* RLC[45] P2A-rlc15
Rrlc45 P2A nrlc45_1 7625.60202879
Lrlc45 nrlc45_1 nrlc45_2 5.22850664227e-05
Crlc45 nrlc45_2 rlc15 5.19020987963e-14
* RLC[49] P3A-P2B
Rrlc49 P3A nrlc49_1 5049.92474062
Lrlc49 nrlc49_1 nrlc49_2 1.0958856074e-05
Crlc49 nrlc49_2 P2B 1.32889883253e-13
* RLC[50] P3A-P3B
Rrlc50 P3A nrlc50_1 613.420470592
Lrlc50 nrlc50_1 nrlc50_2 6.31213418665e-16
Crlc50 nrlc50_2 P3B 4.4904798001e-14
* RLC[51] P3A-P4B
Rrlc51 P3A nrlc51_1 1.3847534409
Lrlc51 nrlc51_1 nrlc51_2 3.63785723028e-09
Crlc51 nrlc51_2 P4B 2.10793995391e-12
* RLC[52] P3A-rlc0
Rrlc52 P3A nrlc52_1 832.199491789
Lrlc52 nrlc52_1 nrlc52_2 1.38066650976e-07
Crlc52 nrlc52_2 rlc0 2.13920959399e-14
* RLC[54] P3A-rlc2
Rrlc54 P3A nrlc54_1 449432.353864
Lrlc54 nrlc54_1 nrlc54_2 7.33401942794e-06
Crlc54 nrlc54_2 rlc2 1.96770709191e-08
* RLC[55] P3A-rlc3
Rrlc55 P3A nrlc55_1 21780.293412
Lrlc55 nrlc55_1 nrlc55_2 0.000595339416609
Crlc55 nrlc55_2 rlc3 8.45829951774e-15
* RLC[58] P3A-rlc6
Rrlc58 P3A nrlc58_1 145.2091511
Lrlc58 nrlc58_1 nrlc58_2 1.59033167214e-06
Crlc58 nrlc58_2 rlc6 8.38025484325e-14
* RLC[59] P3A-rlc7
Rrlc59 P3A nrlc59_1 8688.27243769
Lrlc59 nrlc59_1 nrlc59_2 0.000237949166264
Crlc59 nrlc59_2 rlc7 3.5024731671e-15
* RLC[60] P3A-rlc8
Rrlc60 P3A nrlc60_1 0.990270578538
Lrlc60 nrlc60_1 nrlc60_2 7.41793867631e-09
Crlc60 nrlc60_2 rlc8 8.40490825184e-12
* RLC[66] P3A-rlc14
Rrlc66 P3A nrlc66_1 141678.43995
Lrlc66 nrlc66_1 nrlc66_2 1.08507177825e-10
Crlc66 nrlc66_2 rlc14 4.06910367861e-11
* RLC[67] P3A-rlc15
Rrlc67 P3A nrlc67_1 38.4134392035
Lrlc67 nrlc67_1 nrlc67_2 4.71515333706e-07
Crlc67 nrlc67_2 rlc15 3.55047882994e-13
* RLC[69] P4A-P1B
Rrlc69 P4A nrlc69_1 18.8866120563
Lrlc69 nrlc69_1 nrlc69_2 4.90268985346e-08
Crlc69 nrlc69_2 P1B 1.52715736712e-13
* RLC[70] P4A-P2B
Rrlc70 P4A nrlc70_1 50438.3214524
Lrlc70 nrlc70_1 nrlc70_2 1.19939192991e-05
Crlc70 nrlc70_2 P2B 5.93487970796e-15
* RLC[71] P4A-P3B
Rrlc71 P4A nrlc71_1 3.01288039658
Lrlc71 nrlc71_1 nrlc71_2 4.66304769221e-08
Crlc71 nrlc71_2 P3B 5.70773188708e-12
* RLC[73] P4A-rlc0
Rrlc73 P4A nrlc73_1 20.025608783
Lrlc73 nrlc73_1 nrlc73_2 7.97996246518e-08
Crlc73 nrlc73_2 rlc0 2.21099053766e-13
* RLC[75] P4A-rlc2
Rrlc75 P4A nrlc75_1 7943.09364534
Lrlc75 nrlc75_1 nrlc75_2 8.42817285586e-05
Crlc75 nrlc75_2 rlc2 1.48426538496e-15
* RLC[78] P4A-rlc5
Rrlc78 P4A nrlc78_1 2.51657871199
Lrlc78 nrlc78_1 nrlc78_2 6.32901479419e-09
Crlc78 nrlc78_2 rlc5 1.11038238696e-12
* RLC[79] P4A-rlc6
Rrlc79 P4A nrlc79_1 129638.855777
Lrlc79 nrlc79_1 nrlc79_2 0.828612764257
Crlc79 nrlc79_2 rlc6 2.51707018114e-06
* RLC[80] P4A-rlc7
Rrlc80 P4A nrlc80_1 14867.6458232
Lrlc80 nrlc80_1 nrlc80_2 0.000269511735116
Crlc80 nrlc80_2 rlc7 7.57274597912e-15
* RLC[81] P4A-rlc8
Rrlc81 P4A nrlc81_1 5.3254443401
Lrlc81 nrlc81_1 nrlc81_2 4.16965276363e-08
Crlc81 nrlc81_2 rlc8 1.63359983325e-12
* RLC[84] P4A-rlc11
Rrlc84 P4A nrlc84_1 28808.8510576
Lrlc84 nrlc84_1 nrlc84_2 0.000212953001985
Crlc84 nrlc84_2 rlc11 1.61729459361e-13
* RLC[85] P4A-rlc12
Rrlc85 P4A nrlc85_1 354.272910787
Lrlc85 nrlc85_1 nrlc85_2 3.99801112972e-11
Crlc85 nrlc85_2 rlc12 7.72845339153e-16
* RLC[90] P1B-P2B
Rrlc90 P1B nrlc90_1 1.36014742289
Lrlc90 nrlc90_1 nrlc90_2 3.64964085587e-07
Crlc90 nrlc90_2 P2B 4.93148719944e-07
* RLC[91] P1B-P3B
Rrlc91 P1B nrlc91_1 14.672166138
Lrlc91 nrlc91_1 nrlc91_2 3.17434917794e-08
Crlc91 nrlc91_2 P3B 1.63841424749e-13
* RLC[93] P1B-rlc0
Rrlc93 P1B nrlc93_1 190.310388616
Lrlc93 nrlc93_1 nrlc93_2 3.7748879632e-06
Crlc93 nrlc93_2 rlc0 1.15807467608e-13
* RLC[94] P1B-rlc1
Rrlc94 P1B nrlc94_1 208.458875942
Lrlc94 nrlc94_1 nrlc94_2 2.63520303576e-06
Crlc94 nrlc94_2 rlc1 1.33506060654e-10
* RLC[98] P1B-rlc5
Rrlc98 P1B nrlc98_1 3.46547870157
Lrlc98 nrlc98_1 nrlc98_2 1.71261972592e-08
Crlc98 nrlc98_2 rlc5 1.58449898139e-12
* RLC[100] P1B-rlc7
Rrlc100 P1B nrlc100_1 0.0274171126544
Lrlc100 nrlc100_1 nrlc100_2 4.88835177256e-11
Crlc100 nrlc100_2 rlc7 7.22564313118e-11
* RLC[102] P1B-rlc9
Rrlc102 P1B nrlc102_1 8.48894505646
Lrlc102 nrlc102_1 nrlc102_2 6.19163487981e-08
Crlc102 nrlc102_2 rlc9 3.01527507686e-12
* RLC[104] P1B-rlc11
Rrlc104 P1B nrlc104_1 68.2334772234
Lrlc104 nrlc104_1 nrlc104_2 1.66206518662e-06
Crlc104 nrlc104_2 rlc11 6.6134509107e-05
* RLC[105] P1B-rlc12
Rrlc105 P1B nrlc105_1 8.68083316853
Lrlc105 nrlc105_1 nrlc105_2 1.08687368021e-07
Crlc105 nrlc105_2 rlc12 1.08451217707e-08
* RLC[106] P1B-rlc13
Rrlc106 P1B nrlc106_1 7.08254883526
Lrlc106 nrlc106_1 nrlc106_2 1.17653304091e-08
Crlc106 nrlc106_2 rlc13 1.2395501235e-10
* RLC[107] P1B-rlc14
Rrlc107 P1B nrlc107_1 0.339010545278
Lrlc107 nrlc107_1 nrlc107_2 7.22951930169e-08
Crlc107 nrlc107_2 rlc14 1.04456827694e-07
* RLC[111] P2B-P4B
Rrlc111 P2B nrlc111_1 26.9718462023
Lrlc111 nrlc111_1 nrlc111_2 5.51297063097e-06
Crlc111 nrlc111_2 P4B 4.25146374414e-09
* RLC[115] P2B-rlc3
Rrlc115 P2B nrlc115_1 0.262831345237
Lrlc115 nrlc115_1 nrlc115_2 4.80943352167e-16
Crlc115 nrlc115_2 rlc3 4.29658637093e-12
* RLC[117] P2B-rlc5
Rrlc117 P2B nrlc117_1 200.337161466
Lrlc117 nrlc117_1 nrlc117_2 1.16813323573e-06
Crlc117 nrlc117_2 rlc5 0.000324559429965
* RLC[120] P2B-rlc8
Rrlc120 P2B nrlc120_1 2593.88761099
Lrlc120 nrlc120_1 nrlc120_2 0.001934745967
Crlc120 nrlc120_2 rlc8 0.000348240017672
* RLC[126] P2B-rlc14
Rrlc126 P2B nrlc126_1 2.39069535124
Lrlc126 nrlc126_1 nrlc126_2 5.28389484595e-07
Crlc126 nrlc126_2 rlc14 3.43613705188e-05
* RLC[128] P2B-P1B
Rrlc128 P2B nrlc128_1 6339.62659005
Lrlc128 nrlc128_1 nrlc128_2 8.5373152099e-06
Crlc128 nrlc128_2 P1B 1.31696436407e-14
* RLC[129] P3B-P4B
Rrlc129 P3B nrlc129_1 1.86840508468
Lrlc129 nrlc129_1 nrlc129_2 7.74477170381e-07
Crlc129 nrlc129_2 P4B 6.44537233758e-07
* RLC[130] P3B-rlc0
Rrlc130 P3B nrlc130_1 0.01
Lrlc130 nrlc130_1 nrlc130_2 1.45746223451e-07
Crlc130 nrlc130_2 rlc0 2.84660443439e-05
* RLC[131] P3B-rlc1
Rrlc131 P3B nrlc131_1 261.688558303
Lrlc131 nrlc131_1 nrlc131_2 2.91520414701e-06
Crlc131 nrlc131_2 rlc1 4.72995484252e-14
* RLC[132] P3B-rlc2
Rrlc132 P3B nrlc132_1 318.71329486
Lrlc132 nrlc132_1 nrlc132_2 0.000375465195301
Crlc132 nrlc132_2 rlc2 8.45173718751e-08
* RLC[133] P3B-rlc3
Rrlc133 P3B nrlc133_1 1.59110131622
Lrlc133 nrlc133_1 nrlc133_2 3.43826106037e-09
Crlc133 nrlc133_2 rlc3 1.50903971348e-12
* RLC[134] P3B-rlc4
Rrlc134 P3B nrlc134_1 9.44585428863
Lrlc134 nrlc134_1 nrlc134_2 6.09631695311e-08
Crlc134 nrlc134_2 rlc4 7.5917613092e-13
* RLC[137] P3B-rlc7
Rrlc137 P3B nrlc137_1 221.30179637
Lrlc137 nrlc137_1 nrlc137_2 2.18713468056e-06
Crlc137 nrlc137_2 rlc7 4.96207288604e-14
* RLC[139] P3B-rlc9
Rrlc139 P3B nrlc139_1 334.101613508
Lrlc139 nrlc139_1 nrlc139_2 1.01889751156e-05
Crlc139 nrlc139_2 rlc9 1.01421690729e-13
* RLC[140] P3B-rlc10
Rrlc140 P3B nrlc140_1 7.75924551084
Lrlc140 nrlc140_1 nrlc140_2 5.37256292405e-08
Crlc140 nrlc140_2 rlc10 9.91516655774e-13
* RLC[142] P3B-rlc12
Rrlc142 P3B nrlc142_1 14.7330680312
Lrlc142 nrlc142_1 nrlc142_2 2.68747627257e-06
Crlc142 nrlc142_2 rlc12 1.6511618914e-08
* RLC[143] P3B-rlc13
Rrlc143 P3B nrlc143_1 8.62467879009
Lrlc143 nrlc143_1 nrlc143_2 5.79934701398e-08
Crlc143 nrlc143_2 rlc13 8.66264920034e-13
* RLC[144] P3B-rlc14
Rrlc144 P3B nrlc144_1 5.37784621864
Lrlc144 nrlc144_1 nrlc144_2 1.07745460914e-08
Crlc144 nrlc144_2 rlc14 4.1394221129e-13
* RLC[146] P3B-P1B
Rrlc146 P3B nrlc146_1 20.4205921013
Lrlc146 nrlc146_1 nrlc146_2 1.35048973079e-07
Crlc146 nrlc146_2 P1B 3.59842218675e-13
* RLC[147] P4B-rlc0
Rrlc147 P4B nrlc147_1 13.609695593
Lrlc147 nrlc147_1 nrlc147_2 1.16361274885e-07
Crlc147 nrlc147_2 rlc0 1.91027018224e-12
* RLC[148] P4B-rlc1
Rrlc148 P4B nrlc148_1 13.0362226956
Lrlc148 nrlc148_1 nrlc148_2 8.66490943098e-08
Crlc148 nrlc148_2 rlc1 1.02822098693e-12
* RLC[150] P4B-rlc3
Rrlc150 P4B nrlc150_1 11.4260790568
Lrlc150 nrlc150_1 nrlc150_2 5.33246651296e-08
Crlc150 nrlc150_2 rlc3 4.53827886055e-13
* RLC[152] P4B-rlc5
Rrlc152 P4B nrlc152_1 0.313098558969
Lrlc152 nrlc152_1 nrlc152_2 6.70660688363e-09
Crlc152 nrlc152_2 rlc5 7.60148080793e-11
* RLC[153] P4B-rlc6
Rrlc153 P4B nrlc153_1 771.346742005
Lrlc153 nrlc153_1 nrlc153_2 5.61679107124e-05
Crlc153 nrlc153_2 rlc6 1.04892989022e-13
* RLC[154] P4B-rlc7
Rrlc154 P4B nrlc154_1 28.4258530006
Lrlc154 nrlc154_1 nrlc154_2 6.76887204145e-06
Crlc154 nrlc154_2 rlc7 9.3433858167e-09
* RLC[155] P4B-rlc8
Rrlc155 P4B nrlc155_1 1.58710979209
Lrlc155 nrlc155_1 nrlc155_2 3.43224664049e-08
Crlc155 nrlc155_2 rlc8 2.30614814606e-10
* RLC[156] P4B-rlc9
Rrlc156 P4B nrlc156_1 47.5731181687
Lrlc156 nrlc156_1 nrlc156_2 0.00835590893308
Crlc156 nrlc156_2 rlc9 1.13903058776e-07
* RLC[157] P4B-rlc10
Rrlc157 P4B nrlc157_1 0.299472513804
Lrlc157 nrlc157_1 nrlc157_2 2.08120544843e-09
Crlc157 nrlc157_2 rlc10 2.57844877863e-11
* RLC[160] P4B-rlc13
Rrlc160 P4B nrlc160_1 6.70233768069
Lrlc160 nrlc160_1 nrlc160_2 7.31554998854e-07
Crlc160 nrlc160_2 rlc13 2.22836586286e-07
* RLC[161] P4B-rlc14
Rrlc161 P4B nrlc161_1 74.5053945002
Lrlc161 nrlc161_1 nrlc161_2 3.01261620991e-07
Crlc161 nrlc161_2 rlc14 6.03011871104e-14
* RLC[162] P4B-rlc15
Rrlc162 P4B nrlc162_1 0.0133366814909
Lrlc162 nrlc162_1 nrlc162_2 4.24481486209e-08
Crlc162 nrlc162_2 rlc15 2.01861622721e-06
* RLC[163] P4B-P1B
Rrlc163 P4B nrlc163_1 7.58048981506
Lrlc163 nrlc163_1 nrlc163_2 4.42081760369e-07
Crlc163 nrlc163_2 P1B 2.72937077907e-08
* RLC[164] rlc0-rlc1
Rrlc164 rlc0 nrlc164_1 30.5913164175
Lrlc164 nrlc164_1 nrlc164_2 4.79405539363e-07
Crlc164 nrlc164_2 rlc1 4.20166887078e-11
* RLC[165] rlc0-rlc2
Rrlc165 rlc0 nrlc165_1 166.269335229
Lrlc165 nrlc165_1 nrlc165_2 5.24628750365e-06
Crlc165 nrlc165_2 rlc2 1.31111273827e-12
* RLC[166] rlc0-rlc3
Rrlc166 rlc0 nrlc166_1 0.167015349482
Lrlc166 nrlc166_1 nrlc166_2 1.8654738771e-10
Crlc166 nrlc166_2 rlc3 7.4307711982e-12
* RLC[167] rlc0-rlc4
Rrlc167 rlc0 nrlc167_1 9.4569538495
Lrlc167 nrlc167_1 nrlc167_2 1.46063942042e-07
Crlc167 nrlc167_2 rlc4 1.81470548673e-12
* RLC[168] rlc0-rlc5
Rrlc168 rlc0 nrlc168_1 9070.55710088
Lrlc168 nrlc168_1 nrlc168_2 0.0134358784364
Crlc168 nrlc168_2 rlc5 4.02700656564e-07
* RLC[169] rlc0-rlc6
Rrlc169 rlc0 nrlc169_1 423.930336866
Lrlc169 nrlc169_1 nrlc169_2 9.49262129341e-07
Crlc169 nrlc169_2 rlc6 1.66862066668e-10
* RLC[172] rlc0-rlc9
Rrlc172 rlc0 nrlc172_1 1.22573599193
Lrlc172 nrlc172_1 nrlc172_2 3.55740799414e-08
Crlc172 nrlc172_2 rlc9 2.99726493668e-11
* RLC[176] rlc0-rlc13
Rrlc176 rlc0 nrlc176_1 31.2217189757
Lrlc176 nrlc176_1 nrlc176_2 6.15946833637e-07
Crlc176 nrlc176_2 rlc13 7.02080800702e-13
* RLC[177] rlc0-rlc14
Rrlc177 rlc0 nrlc177_1 1.87758049944
Lrlc177 nrlc177_1 nrlc177_2 3.7602643179e-09
Crlc177 nrlc177_2 rlc14 4.89351128901e-12
* RLC[178] rlc0-rlc15
Rrlc178 rlc0 nrlc178_1 0.861691658623
Lrlc178 nrlc178_1 nrlc178_2 2.50418166538e-08
Crlc178 nrlc178_2 rlc15 1.40737635806e-06
* RLC[179] rlc0-P1B
Rrlc179 rlc0 nrlc179_1 2.33602762148
Lrlc179 nrlc179_1 nrlc179_2 1.40423657094e-08
Crlc179 nrlc179_2 P1B 2.85918214189e-12
* RLC[181] rlc1-rlc3
Rrlc181 rlc1 nrlc181_1 0.298241090424
Lrlc181 nrlc181_1 nrlc181_2 6.1689685463e-10
Crlc181 nrlc181_2 rlc3 7.70610796642e-12
* RLC[182] rlc1-rlc4
Rrlc182 rlc1 nrlc182_1 4.42249672758
Lrlc182 nrlc182_1 nrlc182_2 5.51066952677e-08
Crlc182 nrlc182_2 rlc4 3.1305944963e-12
* RLC[183] rlc1-rlc5
Rrlc183 rlc1 nrlc183_1 177.205463237
Lrlc183 nrlc183_1 nrlc183_2 2.7612598952e-06
Crlc183 nrlc183_2 rlc5 1.19368286921e-11
* RLC[184] rlc1-rlc6
Rrlc184 rlc1 nrlc184_1 486.121222787
Lrlc184 nrlc184_1 nrlc184_2 7.79539958898e-06
Crlc184 nrlc184_2 rlc6 3.94483777219e-13
* RLC[186] rlc1-rlc8
Rrlc186 rlc1 nrlc186_1 0.01
Lrlc186 nrlc186_1 nrlc186_2 1.34995941127e-07
Crlc186 nrlc186_2 rlc8 4.19279232453e-06
* RLC[188] rlc1-rlc10
Rrlc188 rlc1 nrlc188_1 0.936569213714
Lrlc188 nrlc188_1 nrlc188_2 3.46831995131e-10
Crlc188 nrlc188_2 rlc10 1.89802283826e-10
* RLC[189] rlc1-rlc11
Rrlc189 rlc1 nrlc189_1 35.8473066136
Lrlc189 nrlc189_1 nrlc189_2 5.17793199716e-07
Crlc189 nrlc189_2 rlc11 4.47714099997e-13
* RLC[190] rlc1-rlc12
Rrlc190 rlc1 nrlc190_1 216.448979024
Lrlc190 nrlc190_1 nrlc190_2 1.35436931416e-05
Crlc190 nrlc190_2 rlc12 3.76606916338e-09
* RLC[192] rlc1-rlc14
Rrlc192 rlc1 nrlc192_1 15.2084797367
Lrlc192 nrlc192_1 nrlc192_2 1.64433996839e-07
Crlc192 nrlc192_2 rlc14 1.39810566438e-12
* RLC[193] rlc1-rlc15
Rrlc193 rlc1 nrlc193_1 105.986960919
Lrlc193 nrlc193_1 nrlc193_2 4.26916934675e-07
Crlc193 nrlc193_2 rlc15 3.28523124264e-12
* RLC[196] rlc2-rlc4
Rrlc196 rlc2 nrlc196_1 0.0179410782577
Lrlc196 nrlc196_1 nrlc196_2 0.000164725033202
Crlc196 nrlc196_2 rlc4 0.000568617227155
* RLC[198] rlc2-rlc6
Rrlc198 rlc2 nrlc198_1 926.17783169
Lrlc198 nrlc198_1 nrlc198_2 2.81223845201e-05
Crlc198 nrlc198_2 rlc6 3.64267872278e-14
* RLC[199] rlc2-rlc7
Rrlc199 rlc2 nrlc199_1 75.1843258364
Lrlc199 nrlc199_1 nrlc199_2 1.13171573435e-06
Crlc199 nrlc199_2 rlc7 1.03955681764e-12
* RLC[200] rlc2-rlc8
Rrlc200 rlc2 nrlc200_1 156.609410082
Lrlc200 nrlc200_1 nrlc200_2 9.78472304343e-07
Crlc200 nrlc200_2 rlc8 2.41622976913e-12
* RLC[201] rlc2-rlc9
Rrlc201 rlc2 nrlc201_1 3223.40944064
Lrlc201 nrlc201_1 nrlc201_2 0.000110078017301
Crlc201 nrlc201_2 rlc9 1.14050372387e-10
* RLC[202] rlc2-rlc10
Rrlc202 rlc2 nrlc202_1 43.0826810663
Lrlc202 nrlc202_1 nrlc202_2 2.4742991965e-06
Crlc202 nrlc202_2 rlc10 1.48116779564e-12
* RLC[203] rlc2-rlc11
Rrlc203 rlc2 nrlc203_1 257.826074101
Lrlc203 nrlc203_1 nrlc203_2 1.17083126147e-05
Crlc203 nrlc203_2 rlc11 2.448217899e-12
* RLC[204] rlc2-rlc12
Rrlc204 rlc2 nrlc204_1 15.7050533821
Lrlc204 nrlc204_1 nrlc204_2 1.21985393546e-11
Crlc204 nrlc204_2 rlc12 1.47088912987e-11
* RLC[207] rlc2-rlc15
Rrlc207 rlc2 nrlc207_1 8.844890314
Lrlc207 nrlc207_1 nrlc207_2 1.44863167016e-07
Crlc207 nrlc207_2 rlc15 2.41570901211e-12
* RLC[208] rlc2-P1B
Rrlc208 rlc2 nrlc208_1 27.3504791347
Lrlc208 nrlc208_1 nrlc208_2 3.65506050638e-07
Crlc208 nrlc208_2 P1B 5.42902927591e-13
* RLC[210] rlc3-rlc5
Rrlc210 rlc3 nrlc210_1 405.626891818
Lrlc210 nrlc210_1 nrlc210_2 8.27011839068e-06
Crlc210 nrlc210_2 rlc5 5.58490432927e-14
* RLC[211] rlc3-rlc6
Rrlc211 rlc3 nrlc211_1 7539.74592639
Lrlc211 nrlc211_1 nrlc211_2 0.0126884582429
Crlc211 nrlc211_2 rlc6 2.08340157781e-05
* RLC[212] rlc3-rlc7
Rrlc212 rlc3 nrlc212_1 1611.95957459
Lrlc212 nrlc212_1 nrlc212_2 6.00845993689e-06
Crlc212 nrlc212_2 rlc7 5.39261570647e-11
* RLC[213] rlc3-rlc8
Rrlc213 rlc3 nrlc213_1 0.975431652208
Lrlc213 nrlc213_1 nrlc213_2 2.15318053179e-09
Crlc213 nrlc213_2 rlc8 2.51445719515e-12
* RLC[214] rlc3-rlc9
Rrlc214 rlc3 nrlc214_1 128.997264371
Lrlc214 nrlc214_1 nrlc214_2 3.45168356078e-07
Crlc214 nrlc214_2 rlc9 4.92074733522e-11
* RLC[215] rlc3-rlc10
Rrlc215 rlc3 nrlc215_1 0.153187964925
Lrlc215 nrlc215_1 nrlc215_2 3.53331568129e-10
Crlc215 nrlc215_2 rlc10 1.67297957217e-11
* RLC[216] rlc3-rlc11
Rrlc216 rlc3 nrlc216_1 0.542170521181
Lrlc216 nrlc216_1 nrlc216_2 2.44581155508e-11
Crlc216 nrlc216_2 rlc11 9.24503760538e-14
* RLC[218] rlc3-rlc13
Rrlc218 rlc3 nrlc218_1 114.453598531
Lrlc218 nrlc218_1 nrlc218_2 3.06160178787e-06
Crlc218 nrlc218_2 rlc13 2.5968525422e-13
* RLC[219] rlc3-rlc14
Rrlc219 rlc3 nrlc219_1 34.7994946271
Lrlc219 nrlc219_1 nrlc219_2 3.53727800674e-07
Crlc219 nrlc219_2 rlc14 3.24549399889e-13
* RLC[221] rlc3-P1B
Rrlc221 rlc3 nrlc221_1 0.0218062583473
Lrlc221 nrlc221_1 nrlc221_2 4.24180863948e-11
Crlc221 nrlc221_2 P1B 9.91165682299e-11
* RLC[222] rlc4-rlc5
Rrlc222 rlc4 nrlc222_1 12.5286808317
Lrlc222 nrlc222_1 nrlc222_2 8.57125904664e-08
Crlc222 nrlc222_2 rlc5 6.06724342883e-13
* RLC[223] rlc4-rlc6
Rrlc223 rlc4 nrlc223_1 122.362864049
Lrlc223 nrlc223_1 nrlc223_2 2.70291393571e-06
Crlc223 nrlc223_2 rlc6 2.24898553051e-10
* RLC[224] rlc4-rlc7
Rrlc224 rlc4 nrlc224_1 44.8043253
Lrlc224 nrlc224_1 nrlc224_2 3.22618967158e-07
Crlc224 nrlc224_2 rlc7 1.78569590858e-13
* RLC[227] rlc4-rlc10
Rrlc227 rlc4 nrlc227_1 30.0724037328
Lrlc227 nrlc227_1 nrlc227_2 3.82433984754e-07
Crlc227 nrlc227_2 rlc10 1.72605123845e-12
* RLC[228] rlc4-rlc11
Rrlc228 rlc4 nrlc228_1 584.851772214
Lrlc228 nrlc228_1 nrlc228_2 9.03035613334e-06
Crlc228 nrlc228_2 rlc11 6.5004581542e-12
* RLC[229] rlc4-rlc12
Rrlc229 rlc4 nrlc229_1 5.33235920417
Lrlc229 nrlc229_1 nrlc229_2 7.98506962919e-06
Crlc229 nrlc229_2 rlc12 1.22214528539e-07
* RLC[230] rlc4-rlc13
Rrlc230 rlc4 nrlc230_1 0.0265254005525
Lrlc230 nrlc230_1 nrlc230_2 2.98094721068e-12
Crlc230 nrlc230_2 rlc13 4.70747339507e-12
* RLC[231] rlc4-rlc14
Rrlc231 rlc4 nrlc231_1 1.28254123214
Lrlc231 nrlc231_1 nrlc231_2 1.40420512805e-08
Crlc231 nrlc231_2 rlc14 9.48517555072e-12
* RLC[232] rlc4-rlc15
Rrlc232 rlc4 nrlc232_1 1.22471525165
Lrlc232 nrlc232_1 nrlc232_2 3.52103854924e-08
Crlc232 nrlc232_2 rlc15 2.63080138046e-11
* RLC[233] rlc4-P1B
Rrlc233 rlc4 nrlc233_1 0.023085340118
Lrlc233 nrlc233_1 nrlc233_2 1.99218853626e-06
Crlc233 nrlc233_2 P1B 0.001
* RLC[234] rlc5-rlc6
Rrlc234 rlc5 nrlc234_1 58.0232073333
Lrlc234 nrlc234_1 nrlc234_2 1.20632827548e-06
Crlc234 nrlc234_2 rlc6 3.98125078251e-13
* RLC[236] rlc5-rlc8
Rrlc236 rlc5 nrlc236_1 0.157480212829
Lrlc236 nrlc236_1 nrlc236_2 2.87740908794e-08
Crlc236 nrlc236_2 rlc8 1.28916087157e-09
* RLC[240] rlc5-rlc12
Rrlc240 rlc5 nrlc240_1 152.329958558
Lrlc240 nrlc240_1 nrlc240_2 1.16887164922e-05
Crlc240 nrlc240_2 rlc12 5.59697887485e-13
* RLC[241] rlc5-rlc13
Rrlc241 rlc5 nrlc241_1 0.853047181667
Lrlc241 nrlc241_1 nrlc241_2 4.20954065961e-09
Crlc241 nrlc241_2 rlc13 6.42755933289e-12
* RLC[242] rlc5-rlc14
Rrlc242 rlc5 nrlc242_1 167.118031298
Lrlc242 nrlc242_1 nrlc242_2 1.92524818474e-06
Crlc242 nrlc242_2 rlc14 4.35064971545e-10
* RLC[245] rlc6-rlc7
Rrlc245 rlc6 nrlc245_1 58230.5667667
Lrlc245 nrlc245_1 nrlc245_2 0.110226791108
Crlc245 nrlc245_2 rlc7 1.4524000152e-11
* RLC[248] rlc6-rlc10
Rrlc248 rlc6 nrlc248_1 11.9724908736
Lrlc248 nrlc248_1 nrlc248_2 2.54102574276e-07
Crlc248 nrlc248_2 rlc10 1.96968839474e-12
* RLC[249] rlc6-rlc11
Rrlc249 rlc6 nrlc249_1 490.877546407
Lrlc249 nrlc249_1 nrlc249_2 0.000483148929902
Crlc249 nrlc249_2 rlc11 2.22788196689e-12
* RLC[250] rlc6-rlc12
Rrlc250 rlc6 nrlc250_1 562.310121007
Lrlc250 nrlc250_1 nrlc250_2 0.00334529763022
Crlc250 nrlc250_2 rlc12 1.18186562116e-11
* RLC[252] rlc6-rlc14
Rrlc252 rlc6 nrlc252_1 7.58737187195
Lrlc252 nrlc252_1 nrlc252_2 2.5991281563e-07
Crlc252 nrlc252_2 rlc14 5.01651879949e-12
* RLC[253] rlc6-rlc15
Rrlc253 rlc6 nrlc253_1 39.3405749626
Lrlc253 nrlc253_1 nrlc253_2 9.11772609406e-07
Crlc253 nrlc253_2 rlc15 6.54579841006e-13
* RLC[256] rlc7-rlc9
Rrlc256 rlc7 nrlc256_1 23.5851087291
Lrlc256 nrlc256_1 nrlc256_2 3.49937768748e-07
Crlc256 nrlc256_2 rlc9 6.9899254441e-13
* RLC[257] rlc7-rlc10
Rrlc257 rlc7 nrlc257_1 111.417230364
Lrlc257 nrlc257_1 nrlc257_2 9.4343221694e-07
Crlc257 nrlc257_2 rlc10 8.4442965452e-14
* RLC[258] rlc7-rlc11
Rrlc258 rlc7 nrlc258_1 2.6419585168
Lrlc258 nrlc258_1 nrlc258_2 1.10974974307e-06
Crlc258 nrlc258_2 rlc11 1.76656879764e-10
* RLC[259] rlc7-rlc12
Rrlc259 rlc7 nrlc259_1 3.22709227332
Lrlc259 nrlc259_1 nrlc259_2 6.64252163857e-08
Crlc259 nrlc259_2 rlc12 7.08708597606e-12
* RLC[260] rlc7-rlc13
Rrlc260 rlc7 nrlc260_1 37.6109454466
Lrlc260 nrlc260_1 nrlc260_2 1.65541249508e-07
Crlc260 nrlc260_2 rlc13 8.67948381844e-10
* RLC[264] rlc8-rlc9
Rrlc264 rlc8 nrlc264_1 7.83905549447
Lrlc264 nrlc264_1 nrlc264_2 1.1409999454e-07
Crlc264 nrlc264_2 rlc9 4.52937868196e-11
* RLC[265] rlc8-rlc10
Rrlc265 rlc8 nrlc265_1 489.613776628
Lrlc265 nrlc265_1 nrlc265_2 7.84128901607e-06
Crlc265 nrlc265_2 rlc10 7.67692929243e-13
* RLC[267] rlc8-rlc12
Rrlc267 rlc8 nrlc267_1 0.0216782694141
Lrlc267 nrlc267_1 nrlc267_2 0.000422952628311
Crlc267 nrlc267_2 rlc12 0.001
* RLC[268] rlc8-rlc13
Rrlc268 rlc8 nrlc268_1 206.398125724
Lrlc268 nrlc268_1 nrlc268_2 1.48966061587e-05
Crlc268 nrlc268_2 rlc13 3.88537845899e-13
* RLC[269] rlc8-rlc14
Rrlc269 rlc8 nrlc269_1 219.963270853
Lrlc269 nrlc269_1 nrlc269_2 3.11418193674e-06
Crlc269 nrlc269_2 rlc14 4.51676543657e-11
* RLC[270] rlc8-rlc15
Rrlc270 rlc8 nrlc270_1 104.434858667
Lrlc270 nrlc270_1 nrlc270_2 3.23227862239e-06
Crlc270 nrlc270_2 rlc15 3.29287552238e-13
* RLC[272] rlc9-rlc10
Rrlc272 rlc9 nrlc272_1 67.1970866757
Lrlc272 nrlc272_1 nrlc272_2 2.68079820982e-07
Crlc272 nrlc272_2 rlc10 9.45978411692e-12
* RLC[273] rlc9-rlc11
Rrlc273 rlc9 nrlc273_1 304.446919315
Lrlc273 nrlc273_1 nrlc273_2 5.24024648209e-06
Crlc273 nrlc273_2 rlc11 1.30805353277e-11
* RLC[274] rlc9-rlc12
Rrlc274 rlc9 nrlc274_1 5036.24406862
Lrlc274 nrlc274_1 nrlc274_2 1.15445545356e-09
Crlc274 nrlc274_2 rlc12 1.92767912948e-11
* RLC[276] rlc9-rlc14
Rrlc276 rlc9 nrlc276_1 355.618093949
Lrlc276 nrlc276_1 nrlc276_2 4.24727459079e-06
Crlc276 nrlc276_2 rlc14 3.73164335609e-14
* RLC[277] rlc9-rlc15
Rrlc277 rlc9 nrlc277_1 2.11160151113
Lrlc277 nrlc277_1 nrlc277_2 4.09605460092e-09
Crlc277 nrlc277_2 rlc15 6.38470127626e-11
* RLC[279] rlc10-rlc11
Rrlc279 rlc10 nrlc279_1 2375.97412487
Lrlc279 nrlc279_1 nrlc279_2 0.00022943606811
Crlc279 nrlc279_2 rlc11 2.73763788023e-05
* RLC[280] rlc10-rlc12
Rrlc280 rlc10 nrlc280_1 103.15509601
Lrlc280 nrlc280_1 nrlc280_2 7.19307808969e-07
Crlc280 nrlc280_2 rlc12 1.2518455198e-13
* RLC[282] rlc10-rlc14
Rrlc282 rlc10 nrlc282_1 1.84577331043
Lrlc282 nrlc282_1 nrlc282_2 1.54132004588e-08
Crlc282 nrlc282_2 rlc14 5.02682300044e-12
* RLC[284] rlc10-P1B
Rrlc284 rlc10 nrlc284_1 248.364416002
Lrlc284 nrlc284_1 nrlc284_2 5.87121509256e-06
Crlc284 nrlc284_2 P1B 1.05756418646e-13
* RLC[286] rlc11-rlc13
Rrlc286 rlc11 nrlc286_1 463.077183918
Lrlc286 nrlc286_1 nrlc286_2 1.04577857258e-05
Crlc286 nrlc286_2 rlc13 5.41864204533e-14
* RLC[290] rlc12-rlc13
Rrlc290 rlc12 nrlc290_1 0.01
Lrlc290 nrlc290_1 nrlc290_2 1.02033700312e-08
Crlc290 nrlc290_2 rlc13 0.000912756997907
* RLC[291] rlc12-rlc14
Rrlc291 rlc12 nrlc291_1 55.3604194065
Lrlc291 nrlc291_1 nrlc291_2 3.94670605598e-07
Crlc291 nrlc291_2 rlc14 4.509642276e-11
* RLC[292] rlc12-rlc15
Rrlc292 rlc12 nrlc292_1 112.465418307
Lrlc292 nrlc292_1 nrlc292_2 3.09980402019e-05
Crlc292 nrlc292_2 rlc15 2.73999648309e-08
* RLC[293] rlc12-P1B
Rrlc293 rlc12 nrlc293_1 20.4783187724
Lrlc293 nrlc293_1 nrlc293_2 2.75856366087e-07
Crlc293 nrlc293_2 P1B 4.64750620904e-10
* RLC[294] rlc13-rlc14
Rrlc294 rlc13 nrlc294_1 24.3040636999
Lrlc294 nrlc294_1 nrlc294_2 5.1890879935e-06
Crlc294 nrlc294_2 rlc14 4.9489370375e-09
* RLC[295] rlc13-rlc15
Rrlc295 rlc13 nrlc295_1 5.62686549124
Lrlc295 nrlc295_1 nrlc295_2 5.76884893349e-07
Crlc295 nrlc295_2 rlc15 3.20986690533e-08
* RLC[296] rlc13-P1B
Rrlc296 rlc13 nrlc296_1 0.0318134977376
Lrlc296 nrlc296_1 nrlc296_2 1.56217772303e-10
Crlc296 nrlc296_2 P1B 1.71500381476e-10
* RLC[297] rlc14-rlc15
Rrlc297 rlc14 nrlc297_1 163.575336989
Lrlc297 nrlc297_1 nrlc297_2 7.42096376966e-07
Crlc297 nrlc297_2 rlc15 3.11653690757e-12
* RLC[298] rlc14-P1B
Rrlc298 rlc14 nrlc298_1 217.784561713
Lrlc298 nrlc298_1 nrlc298_2 3.19838031353e-06
Crlc298 nrlc298_2 P1B 7.49261493447e-14
* RLC[299] rlc15-P1B
Rrlc299 rlc15 nrlc299_1 5.88587392341
Lrlc299 nrlc299_1 nrlc299_2 4.4736494645e-07
Crlc299 nrlc299_2 P1B 2.19587305563e-08
* DC[0] P1A-P2A
Rdc0 P1A ndc0_1 0.0274719071521
Ldc0 ndc0_1 P2A 5.38558786163e-08
* DC[23] P3A-P4A
Rdc23 P3A ndc23_1 0.0833312689471
Ldc23 ndc23_1 P4A 7.68973543261e-08
* DC[25] P3A-P2B
Rdc25 P3A ndc25_1 1704849.12992
Ldc25 ndc25_1 P2B 0.271335166253
* DC[42] P1B-P2B
Rdc42 P1B ndc42_1 0.231586905367
Ldc42 ndc42_1 P2B 8.72720384617e-08
* DC[43] P1B-P3B
Rdc43 P1B ndc43_1 49.4865055931
Ldc43 ndc43_1 P3B 7.87602198149e-06
* DC[46] P1B-dc1
Rdc46 P1B ndc46_1 35.3936349421
Ldc46 ndc46_1 dc1 1.92877401091e-05
* DC[48] P1B-dc3
Rdc48 P1B ndc48_1 4.29049392144
Ldc48 ndc48_1 dc3 6.82853315904e-07
* DC[51] P2B-P4B
Rdc51 P2B ndc51_1 1.44744638715
Ldc51 ndc51_1 P4B 2.99647362956e-07
* DC[54] P2B-dc2
Rdc54 P2B ndc54_1 7.02129592482
Ldc54 ndc54_1 dc2 1.59277892653e-06
* DC[56] P2B-P1B
Rdc56 P2B ndc56_1 0.230170519715
Ldc56 ndc56_1 P1B 8.67382826227e-08
* DC[57] P3B-P4B
Rdc57 P3B ndc57_1 0.165808155268
Ldc57 ndc57_1 P4B 9.80024868031e-08
* DC[59] P3B-dc1
Rdc59 P3B ndc59_1 0.993125476007
Ldc59 ndc59_1 dc1 5.26866089329e-07
* DC[60] P3B-dc2
Rdc60 P3B ndc60_1 9.90124554307
Ldc60 ndc60_1 dc2 7.22818940241e-06
* DC[61] P3B-dc3
Rdc61 P3B ndc61_1 1.92131621315
Ldc61 ndc61_1 dc3 3.05786972565e-07
* DC[62] P3B-P1B
Rdc62 P3B ndc62_1 7.46548994162
Ldc62 ndc62_1 P1B 1.18816962681e-06
* DC[63] P4B-dc0
Rdc63 P4B ndc63_1 0.0764087104896
Ldc63 ndc63_1 dc0 1.21608239697e-08
* DC[64] P4B-dc1
Rdc64 P4B ndc64_1 0.0101293949704
Ldc64 ndc64_1 dc1 1.37663279901e-08
* DC[65] P4B-dc2
Rdc65 P4B ndc65_1 0.103964759874
Ldc65 ndc65_1 dc2 1.65465054414e-08
* DC[67] P4B-P1B
Rdc67 P4B ndc67_1 60.8115369801
Ldc67 ndc67_1 P1B 1.54199268319e-05
* DC[69] dc0-dc2
Rdc69 dc0 ndc69_1 0.059538544555
Ldc69 ndc69_1 dc2 9.47585367043e-09
* DC[71] dc0-P1B
Rdc71 dc0 ndc71_1 30.6259019197
Ldc71 ndc71_1 P1B 1.84927884207e-05
* DC[73] dc1-dc3
Rdc73 dc1 ndc73_1 0.014407167894
Ldc73 ndc73_1 dc3 5.31220938147e-07
* DC[74] dc1-P1B
Rdc74 dc1 ndc74_1 108.067114858
Ldc74 ndc74_1 P1B 2.00095593065e-05
* DC[75] dc2-dc3
Rdc75 dc2 ndc75_1 0.0371383920884
Ldc75 ndc75_1 dc3 4.17224345981e-06
* DC[76] dc2-P1B
Rdc76 dc2 ndc76_1 13.4339485784
Ldc76 ndc76_1 P1B 8.22241368004e-06
* ---- leaks
Rleak_P1A P1A P1B 1e+12
Rleak_P2A P2A P1B 1e+12
Rleak_P2B P2B P1B 1e+12
Rleak_P3A P3A P1B 1e+12
Rleak_P3B P3B P1B 1e+12
Rleak_P4A P4A P1B 1e+12
Rleak_P4B P4B P1B 1e+12
Rleak_dc0 dc0 P1B 1e+12
Rleak_dc1 dc1 P1B 1e+12
Rleak_dc2 dc2 P1B 1e+12
Rleak_dc3 dc3 P1B 1e+12
Rleak_rlc0 rlc0 P1B 1e+12
Rleak_rlc1 rlc1 P1B 1e+12
Rleak_rlc10 rlc10 P1B 1e+12
Rleak_rlc11 rlc11 P1B 1e+12
Rleak_rlc12 rlc12 P1B 1e+12
Rleak_rlc13 rlc13 P1B 1e+12
Rleak_rlc14 rlc14 P1B 1e+12
Rleak_rlc15 rlc15 P1B 1e+12
Rleak_rlc2 rlc2 P1B 1e+12
Rleak_rlc3 rlc3 P1B 1e+12
Rleak_rlc4 rlc4 P1B 1e+12
Rleak_rlc5 rlc5 P1B 1e+12
Rleak_rlc6 rlc6 P1B 1e+12
Rleak_rlc7 rlc7 P1B 1e+12
Rleak_rlc8 rlc8 P1B 1e+12
Rleak_rlc9 rlc9 P1B 1e+12
.ends fitted
