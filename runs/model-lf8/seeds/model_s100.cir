* fitted: 8-port fitted model, reference z0 = 50 Ohm
* every pin is a port against GND
.subckt fitted P1A P1B P2A P2B P3A P3B P4A P4B GND
* ---- branches
* RLC[2] P1A-P4A
Rrlc2 P1A nrlc2_1 4412.53363481
Lrlc2 nrlc2_1 nrlc2_2 0.538079825346
Crlc2 nrlc2_2 P4A 3.07063461852e-11
* RLC[7] P1A-rlc0
Rrlc7 P1A nrlc7_1 83.2880671615
Lrlc7 nrlc7_1 nrlc7_2 0.702977577073
Crlc7 nrlc7_2 rlc0 1.85192786759e-07
* RLC[10] P1A-rlc3
Rrlc10 P1A nrlc10_1 4790.89186083
Lrlc10 nrlc10_1 nrlc10_2 1
Crlc10 nrlc10_2 rlc3 4.84088487283e-11
* RLC[14] P1A-rlc7
Rrlc14 P1A nrlc14_1 31.8356075723
Lrlc14 nrlc14_1 nrlc14_2 5.85891690268e-09
Crlc14 nrlc14_2 rlc7 3.26644436907e-10
* RLC[18] P1A-rlc11
Rrlc18 P1A nrlc18_1 66.5567864778
Lrlc18 nrlc18_1 nrlc18_2 8.52963465179e-07
Crlc18 nrlc18_2 rlc11 1.29641612249e-09
* RLC[20] P1A-rlc13
Rrlc20 P1A nrlc20_1 60.1410527883
Lrlc20 nrlc20_1 nrlc20_2 0.0219658245602
Crlc20 nrlc20_2 rlc13 6.7478116008e-09
* RLC[21] P1A-rlc14
Rrlc21 P1A nrlc21_1 978.718407431
Lrlc21 nrlc21_1 nrlc21_2 1
Crlc21 nrlc21_2 rlc14 1.1599572338e-09
* RLC[24] P2A-P3A
Rrlc24 P2A nrlc24_1 93759203.2416
Lrlc24 nrlc24_1 nrlc24_2 0.389829195284
Crlc24 nrlc24_2 P3A 0.001
* RLC[25] P2A-P4A
Rrlc25 P2A nrlc25_1 82.658748316
Lrlc25 nrlc25_1 nrlc25_2 3.00598930029e-11
Crlc25 nrlc25_2 P4A 6.2435437329e-12
* RLC[26] P2A-P1B
Rrlc26 P2A nrlc26_1 601894.555683
Lrlc26 nrlc26_1 nrlc26_2 2.03119103689e-05
Crlc26 nrlc26_2 P1B 0.001
* RLC[28] P2A-P3B
Rrlc28 P2A nrlc28_1 705931.031472
Lrlc28 nrlc28_1 nrlc28_2 1
Crlc28 nrlc28_2 P3B 0.001
* RLC[29] P2A-P4B
Rrlc29 P2A nrlc29_1 126.524102651
Lrlc29 nrlc29_1 nrlc29_2 2.18113026327e-06
Crlc29 nrlc29_2 P4B 1.21582280839e-10
* RLC[32] P2A-rlc2
Rrlc32 P2A nrlc32_1 443.935799615
Lrlc32 nrlc32_1 nrlc32_2 1
Crlc32 nrlc32_2 rlc2 5.63789720836e-09
* RLC[33] P2A-rlc3
Rrlc33 P2A nrlc33_1 562.199983663
Lrlc33 nrlc33_1 nrlc33_2 0.629799225382
Crlc33 nrlc33_2 rlc3 2.21400172748e-09
* RLC[35] P2A-rlc5
Rrlc35 P2A nrlc35_1 100.954044884
Lrlc35 nrlc35_1 nrlc35_2 0.878918466884
Crlc35 nrlc35_2 rlc5 9.58217554866e-08
* RLC[36] P2A-rlc6
Rrlc36 P2A nrlc36_1 211.243275038
Lrlc36 nrlc36_1 nrlc36_2 0.0457378412004
Crlc36 nrlc36_2 rlc6 1.13885220985e-09
* RLC[38] P2A-rlc8
Rrlc38 P2A nrlc38_1 38.4936383525
Lrlc38 nrlc38_1 nrlc38_2 0.00482068108803
Crlc38 nrlc38_2 rlc8 3.61483075543e-09
* RLC[40] P2A-rlc10
Rrlc40 P2A nrlc40_1 14.6186887922
Lrlc40 nrlc40_1 nrlc40_2 0.000113945830493
Crlc40 nrlc40_2 rlc10 5.92432788938e-10
* RLC[41] P2A-rlc11
Rrlc41 P2A nrlc41_1 0.0536339937105
Lrlc41 nrlc41_1 nrlc41_2 1.77112120936e-13
Crlc41 nrlc41_2 rlc11 2.59153545289e-10
* RLC[43] P2A-rlc13
Rrlc43 P2A nrlc43_1 415.773145174
Lrlc43 nrlc43_1 nrlc43_2 2.29104123327e-05
Crlc43 nrlc43_2 rlc13 4.36618982311e-10
* RLC[46] P2A-GND
Rrlc46 P2A nrlc46_1 1484.29121851
Lrlc46 nrlc46_1 nrlc46_2 2.65865414658e-06
Crlc46 nrlc46_2 GND 2.92142045105e-13
* RLC[47] P3A-P4A
Rrlc47 P3A nrlc47_1 2.91837487777
Lrlc47 nrlc47_1 nrlc47_2 7.53534310402e-07
Crlc47 nrlc47_2 P4A 6.01956879568e-07
* RLC[48] P3A-P1B
Rrlc48 P3A nrlc48_1 165.051707903
Lrlc48 nrlc48_1 nrlc48_2 3.04763642675e-06
Crlc48 nrlc48_2 P1B 1.46607001098e-10
* RLC[50] P3A-P3B
Rrlc50 P3A nrlc50_1 125.727671752
Lrlc50 nrlc50_1 nrlc50_2 1.50688098416e-06
Crlc50 nrlc50_2 P3B 6.1958490458e-11
* RLC[51] P3A-P4B
Rrlc51 P3A nrlc51_1 1.28510836785
Lrlc51 nrlc51_1 nrlc51_2 6.26466559752e-08
Crlc51 nrlc51_2 P4B 4.21478942108e-11
* RLC[53] P3A-rlc1
Rrlc53 P3A nrlc53_1 20.9398703364
Lrlc53 nrlc53_1 nrlc53_2 3.46226816829e-06
Crlc53 nrlc53_2 rlc1 5.48761025192e-10
* RLC[57] P3A-rlc5
Rrlc57 P3A nrlc57_1 329825.760772
Lrlc57 nrlc57_1 nrlc57_2 1
Crlc57 nrlc57_2 rlc5 0.001
* RLC[62] P3A-rlc10
Rrlc62 P3A nrlc62_1 59.5118347396
Lrlc62 nrlc62_1 nrlc62_2 0.117581897731
Crlc62 nrlc62_2 rlc10 3.68885238345e-08
* RLC[65] P3A-rlc13
Rrlc65 P3A nrlc65_1 0.272805218622
Lrlc65 nrlc65_1 nrlc65_2 2.59129415982e-08
Crlc65 nrlc65_2 rlc13 3.86873389998e-10
* RLC[66] P3A-rlc14
Rrlc66 P3A nrlc66_1 793.015501182
Lrlc66 nrlc66_1 nrlc66_2 0.056421969092
Crlc66 nrlc66_2 rlc14 9.96878836269e-11
* RLC[69] P4A-P1B
Rrlc69 P4A nrlc69_1 14.1759110894
Lrlc69 nrlc69_1 nrlc69_2 2.92408630837e-14
Crlc69 nrlc69_2 P1B 3.1339541551e-12
* RLC[70] P4A-P2B
Rrlc70 P4A nrlc70_1 159.144158912
Lrlc70 nrlc70_1 nrlc70_2 3.12039624317e-06
Crlc70 nrlc70_2 P2B 1.05284110853e-10
* RLC[71] P4A-P3B
Rrlc71 P4A nrlc71_1 52.22625731
Lrlc71 nrlc71_1 nrlc71_2 2.39751231808e-09
Crlc71 nrlc71_2 P3B 5.33607302277e-11
* RLC[72] P4A-P4B
Rrlc72 P4A nrlc72_1 111.283656512
Lrlc72 nrlc72_1 nrlc72_2 1.77330481728e-06
Crlc72 nrlc72_2 P4B 6.78803133127e-11
* RLC[79] P4A-rlc6
Rrlc79 P4A nrlc79_1 163.887297385
Lrlc79 nrlc79_1 nrlc79_2 0.0758602942364
Crlc79 nrlc79_2 rlc6 3.13820584142e-09
* RLC[80] P4A-rlc7
Rrlc80 P4A nrlc80_1 183.846105707
Lrlc80 nrlc80_1 nrlc80_2 1.8385318604e-05
Crlc80 nrlc80_2 rlc7 4.90840807225e-10
* RLC[81] P4A-rlc8
Rrlc81 P4A nrlc81_1 15.9392987775
Lrlc81 nrlc81_1 nrlc81_2 4.21966787318e-14
Crlc81 nrlc81_2 rlc8 4.92687142176e-10
* RLC[82] P4A-rlc9
Rrlc82 P4A nrlc82_1 117.827947216
Lrlc82 nrlc82_1 nrlc82_2 0.929746200814
Crlc82 nrlc82_2 rlc9 7.44089677757e-08
* RLC[83] P4A-rlc10
Rrlc83 P4A nrlc83_1 2628.15974295
Lrlc83 nrlc83_1 nrlc83_2 0.312530201056
Crlc83 nrlc83_2 rlc10 5.02742921509e-11
* RLC[86] P4A-rlc13
Rrlc86 P4A nrlc86_1 5784.24534818
Lrlc86 nrlc86_1 nrlc86_2 1
Crlc86 nrlc86_2 rlc13 3.32096331804e-11
* RLC[89] P4A-GND
Rrlc89 P4A nrlc89_1 392.25967044
Lrlc89 nrlc89_1 nrlc89_2 1.02098664741e-06
Crlc89 nrlc89_2 GND 1.27941380835e-12
* RLC[90] P1B-P2B
Rrlc90 P1B nrlc90_1 0.118694770873
Lrlc90 nrlc90_1 nrlc90_2 1.39019192717e-07
Crlc90 nrlc90_2 P2B 3.87337559101e-05
* RLC[91] P1B-P3B
Rrlc91 P1B nrlc91_1 0.01
Lrlc91 nrlc91_1 nrlc91_2 1.34991386807e-08
Crlc91 nrlc91_2 P3B 0.001
* RLC[92] P1B-P4B
Rrlc92 P1B nrlc92_1 12.729767514
Lrlc92 nrlc92_1 nrlc92_2 1.79243454255e-14
Crlc92 nrlc92_2 P4B 8.70718519938e-11
* RLC[93] P1B-rlc0
Rrlc93 P1B nrlc93_1 99.3675554732
Lrlc93 nrlc93_1 nrlc93_2 0.00365000307133
Crlc93 nrlc93_2 rlc0 4.10734807614e-10
* RLC[94] P1B-rlc1
Rrlc94 P1B nrlc94_1 539.621343153
Lrlc94 nrlc94_1 nrlc94_2 0.858360890252
Crlc94 nrlc94_2 rlc1 3.2752855931e-09
* RLC[99] P1B-rlc6
Rrlc99 P1B nrlc99_1 2.25524159104
Lrlc99 nrlc99_1 nrlc99_2 0.0161411516962
Crlc99 nrlc99_2 rlc6 3.74106778844e-06
* RLC[101] P1B-rlc8
Rrlc101 P1B nrlc101_1 97.7173063961
Lrlc101 nrlc101_1 nrlc101_2 0.0169271056767
Crlc101 nrlc101_2 rlc8 1.96968701582e-09
* RLC[103] P1B-rlc10
Rrlc103 P1B nrlc103_1 76.3563066546
Lrlc103 nrlc103_1 nrlc103_2 0.0193553512929
Crlc103 nrlc103_2 rlc10 3.6886608105e-09
* RLC[106] P1B-rlc13
Rrlc106 P1B nrlc106_1 11.8564875796
Lrlc106 nrlc106_1 nrlc106_2 0.199975981021
Crlc106 nrlc106_2 rlc13 1.58060454048e-06
* RLC[108] P1B-rlc15
Rrlc108 P1B nrlc108_1 11.4181592846
Lrlc108 nrlc108_1 nrlc108_2 1.45285808077e-07
Crlc108 nrlc108_2 rlc15 1.35048886071e-09
* RLC[112] P2B-rlc0
Rrlc112 P2B nrlc112_1 0.01
Lrlc112 nrlc112_1 nrlc112_2 2.47438473834e-15
Crlc112 nrlc112_2 rlc0 4.31392193466e-10
* RLC[113] P2B-rlc1
Rrlc113 P2B nrlc113_1 211.304897177
Lrlc113 nrlc113_1 nrlc113_2 0.363807151328
Crlc113 nrlc113_2 rlc1 9.05335598726e-09
* RLC[114] P2B-rlc2
Rrlc114 P2B nrlc114_1 0.01
Lrlc114 nrlc114_1 nrlc114_2 3.62864220602e-11
Crlc114 nrlc114_2 rlc2 1.1805688918e-09
* RLC[116] P2B-rlc4
Rrlc116 P2B nrlc116_1 614.491391919
Lrlc116 nrlc116_1 nrlc116_2 1
Crlc116 nrlc116_2 rlc4 2.94256377111e-09
* RLC[120] P2B-rlc8
Rrlc120 P2B nrlc120_1 3.08617677547
Lrlc120 nrlc120_1 nrlc120_2 0.175292532261
Crlc120 nrlc120_2 rlc8 2.04493405746e-05
* RLC[121] P2B-rlc9
Rrlc121 P2B nrlc121_1 2.64497597512
Lrlc121 nrlc121_1 nrlc121_2 0.00145170511406
Crlc121 nrlc121_2 rlc9 2.30564496979e-07
* RLC[125] P2B-rlc13
Rrlc125 P2B nrlc125_1 134.273653331
Lrlc125 nrlc125_1 nrlc125_2 0.999966381687
Crlc125 nrlc125_2 rlc13 6.2090301374e-08
* RLC[126] P2B-rlc14
Rrlc126 P2B nrlc126_1 449.916984901
Lrlc126 nrlc126_1 nrlc126_2 0.974833164628
Crlc126 nrlc126_2 rlc14 5.35085286541e-09
* RLC[137] P3B-rlc7
Rrlc137 P3B nrlc137_1 561.820395503
Lrlc137 nrlc137_1 nrlc137_2 1
Crlc137 nrlc137_2 rlc7 3.52016068564e-09
* RLC[138] P3B-rlc8
Rrlc138 P3B nrlc138_1 6.40887596215
Lrlc138 nrlc138_1 nrlc138_2 0.056743011475
Crlc138 nrlc138_2 rlc8 1.53509886441e-06
* RLC[140] P3B-rlc10
Rrlc140 P3B nrlc140_1 31.6178073335
Lrlc140 nrlc140_1 nrlc140_2 1.85447090984e-05
Crlc140 nrlc140_2 rlc10 2.06117097555e-11
* RLC[143] P3B-rlc13
Rrlc143 P3B nrlc143_1 1.06519182647
Lrlc143 nrlc143_1 nrlc143_2 7.35903602162e-05
Crlc143 nrlc143_2 rlc13 7.20647308068e-08
* RLC[144] P3B-rlc14
Rrlc144 P3B nrlc144_1 0.234401689789
Lrlc144 nrlc144_1 nrlc144_2 0.0494496763243
Crlc144 nrlc144_2 rlc14 0.000999998773826
* RLC[145] P3B-rlc15
Rrlc145 P3B nrlc145_1 24.9603315038
Lrlc145 nrlc145_1 nrlc145_2 1.78777140494e-09
Crlc145 nrlc145_2 rlc15 7.29046936542e-10
* RLC[148] P4B-rlc1
Rrlc148 P4B nrlc148_1 0.538511808518
Lrlc148 nrlc148_1 nrlc148_2 6.75183764605e-07
Crlc148 nrlc148_2 rlc1 2.58695586442e-09
* RLC[151] P4B-rlc4
Rrlc151 P4B nrlc151_1 100.134172564
Lrlc151 nrlc151_1 nrlc151_2 0.516296662028
Crlc151 nrlc151_2 rlc4 5.72126653844e-08
* RLC[153] P4B-rlc6
Rrlc153 P4B nrlc153_1 3.45952745396
Lrlc153 nrlc153_1 nrlc153_2 0.0540099595404
Crlc153 nrlc153_2 rlc6 5.02031827528e-06
* RLC[155] P4B-rlc8
Rrlc155 P4B nrlc155_1 3009.67653492
Lrlc155 nrlc155_1 nrlc155_2 0.992480893864
Crlc155 nrlc155_2 rlc8 0.001
* RLC[159] P4B-rlc12
Rrlc159 P4B nrlc159_1 593.655635717
Lrlc159 nrlc159_1 nrlc159_2 1
Crlc159 nrlc159_2 rlc12 3.15274104295e-09
* RLC[161] P4B-rlc14
Rrlc161 P4B nrlc161_1 4.34773543069
Lrlc161 nrlc161_1 nrlc161_2 0.0050430026044
Crlc161 nrlc161_2 rlc14 2.96428847926e-07
* RLC[164] rlc0-rlc1
Rrlc164 rlc0 nrlc164_1 0.01
Lrlc164 nrlc164_1 nrlc164_2 2.64766548322e-15
Crlc164 nrlc164_2 rlc1 1.63043476165e-07
* RLC[165] rlc0-rlc2
Rrlc165 rlc0 nrlc165_1 1.00285938306
Lrlc165 nrlc165_1 nrlc165_2 0.905154247974
Crlc165 nrlc165_2 rlc2 0.001
* RLC[167] rlc0-rlc4
Rrlc167 rlc0 nrlc167_1 0.188882636897
Lrlc167 nrlc167_1 nrlc167_2 0.000649445476456
Crlc167 nrlc167_2 rlc4 2.02262845421e-05
* RLC[169] rlc0-rlc6
Rrlc169 rlc0 nrlc169_1 218.080434754
Lrlc169 nrlc169_1 nrlc169_2 0.999998456582
Crlc169 nrlc169_2 rlc6 2.33627204128e-08
* RLC[170] rlc0-rlc7
Rrlc170 rlc0 nrlc170_1 0.78752482519
Lrlc170 nrlc170_1 nrlc170_2 0.558175815261
Crlc170 nrlc170_2 rlc7 0.001
* RLC[172] rlc0-rlc9
Rrlc172 rlc0 nrlc172_1 1.3639491597
Lrlc172 nrlc172_1 nrlc172_2 0.000865882437795
Crlc172 nrlc172_2 rlc9 5.1715420057e-07
* RLC[173] rlc0-rlc10
Rrlc173 rlc0 nrlc173_1 1.05364711306
Lrlc173 nrlc173_1 nrlc173_2 0.999155014983
Crlc173 nrlc173_2 rlc10 0.001
* RLC[175] rlc0-rlc12
Rrlc175 rlc0 nrlc175_1 14.1344378055
Lrlc175 nrlc175_1 nrlc175_2 0.241198203341
Crlc175 nrlc175_2 rlc12 1.34147523015e-06
* RLC[176] rlc0-rlc13
Rrlc176 rlc0 nrlc176_1 49.1776481355
Lrlc176 nrlc176_1 nrlc176_2 0.99918420012
Crlc176 nrlc176_2 rlc13 4.59057976542e-07
* RLC[177] rlc0-rlc14
Rrlc177 rlc0 nrlc177_1 930.486576874
Lrlc177 nrlc177_1 nrlc177_2 1
Crlc177 nrlc177_2 rlc14 1.28332680562e-09
* RLC[178] rlc0-rlc15
Rrlc178 rlc0 nrlc178_1 19.883715184
Lrlc178 nrlc178_1 nrlc178_2 0.999730613281
Crlc178 nrlc178_2 rlc15 2.80960595261e-06
* RLC[182] rlc1-rlc4
Rrlc182 rlc1 nrlc182_1 1279.42974415
Lrlc182 nrlc182_1 nrlc182_2 1
Crlc182 nrlc182_2 rlc4 6.78773071668e-10
* RLC[185] rlc1-rlc7
Rrlc185 rlc1 nrlc185_1 26.974583288
Lrlc185 nrlc185_1 nrlc185_2 4.31128603263e-07
Crlc185 nrlc185_2 rlc7 1.29104206769e-09
* RLC[186] rlc1-rlc8
Rrlc186 rlc1 nrlc186_1 1.05409255339
Lrlc186 nrlc186_1 nrlc186_2 1
Crlc186 nrlc186_2 rlc8 0.001
* RLC[187] rlc1-rlc9
Rrlc187 rlc1 nrlc187_1 7.72916413646
Lrlc187 nrlc187_1 nrlc187_2 0.0926039849618
Crlc187 nrlc187_2 rlc9 1.72235279686e-06
* RLC[188] rlc1-rlc10
Rrlc188 rlc1 nrlc188_1 38.7606749259
Lrlc188 nrlc188_1 nrlc188_2 0.252691240889
Crlc188 nrlc188_2 rlc10 1.86891874516e-07
* RLC[191] rlc1-rlc13
Rrlc191 rlc1 nrlc191_1 81.2540137966
Lrlc191 nrlc191_1 nrlc191_2 0.988485245266
Crlc191 nrlc191_2 rlc13 1.66412405337e-07
* RLC[195] rlc2-rlc3
Rrlc195 rlc2 nrlc195_1 14.1380881796
Lrlc195 nrlc195_1 nrlc195_2 0.999965528987
Crlc195 nrlc195_2 rlc3 5.5585452784e-06
* RLC[196] rlc2-rlc4
Rrlc196 rlc2 nrlc196_1 26.0420565538
Lrlc196 nrlc196_1 nrlc196_2 0.607816125103
Crlc196 nrlc196_2 rlc4 9.95816121092e-07
* RLC[197] rlc2-rlc5
Rrlc197 rlc2 nrlc197_1 4.75007412924
Lrlc197 nrlc197_1 nrlc197_2 0.000691775702961
Crlc197 nrlc197_2 rlc5 3.40660688974e-08
* RLC[198] rlc2-rlc6
Rrlc198 rlc2 nrlc198_1 0.0257947275113
Lrlc198 nrlc198_1 nrlc198_2 1.22544541238e-08
Crlc198 nrlc198_2 rlc6 2.0463954992e-08
* RLC[199] rlc2-rlc7
Rrlc199 rlc2 nrlc199_1 1.37880177347
Lrlc199 nrlc199_1 nrlc199_2 0.745198245905
Crlc199 nrlc199_2 rlc7 0.000435537594169
* RLC[201] rlc2-rlc9
Rrlc201 rlc2 nrlc201_1 39.4505558283
Lrlc201 nrlc201_1 nrlc201_2 0.981276019593
Crlc201 nrlc201_2 rlc9 7.00555300446e-07
* RLC[203] rlc2-rlc11
Rrlc203 rlc2 nrlc203_1 0.801592931463
Lrlc203 nrlc203_1 nrlc203_2 2.46940799403e-06
Crlc203 nrlc203_2 rlc11 4.27014460707e-09
* RLC[205] rlc2-rlc13
Rrlc205 rlc2 nrlc205_1 1.69760222089
Lrlc205 nrlc205_1 nrlc205_2 0.9999095897
Crlc205 nrlc205_2 rlc13 0.00038551950409
* RLC[209] rlc3-rlc4
Rrlc209 rlc3 nrlc209_1 1.05393214291
Lrlc209 nrlc209_1 nrlc209_2 0.999695665665
Crlc209 nrlc209_2 rlc4 0.001
* RLC[211] rlc3-rlc6
Rrlc211 rlc3 nrlc211_1 1.05409255339
Lrlc211 nrlc211_1 nrlc211_2 1
Crlc211 nrlc211_2 rlc6 0.001
* RLC[212] rlc3-rlc7
Rrlc212 rlc3 nrlc212_1 1.62789943261
Lrlc212 nrlc212_1 nrlc212_2 0.999807081842
Crlc212 nrlc212_2 rlc7 0.000419197376101
* RLC[215] rlc3-rlc10
Rrlc215 rlc3 nrlc215_1 219.380055574
Lrlc215 nrlc215_1 nrlc215_2 0.456620808187
Crlc215 nrlc215_2 rlc10 1.05419003014e-08
* RLC[216] rlc3-rlc11
Rrlc216 rlc3 nrlc216_1 0.157535812573
Lrlc216 nrlc216_1 nrlc216_2 0.000275242256983
Crlc216 nrlc216_2 rlc11 1.23229307002e-05
* RLC[218] rlc3-rlc13
Rrlc218 rlc3 nrlc218_1 0.689093742846
Lrlc218 nrlc218_1 nrlc218_2 0.00862776168858
Crlc218 nrlc218_2 rlc13 2.01882660051e-05
* RLC[219] rlc3-rlc14
Rrlc219 rlc3 nrlc219_1 4.03825436148
Lrlc219 nrlc219_1 nrlc219_2 0.168502614187
Crlc219 nrlc219_2 rlc14 1.14809226754e-05
* RLC[220] rlc3-rlc15
Rrlc220 rlc3 nrlc220_1 0.0349722400374
Lrlc220 nrlc220_1 nrlc220_2 6.42049171173e-06
Crlc220 nrlc220_2 rlc15 5.83282409251e-06
* RLC[222] rlc4-rlc5
Rrlc222 rlc4 nrlc222_1 0.162318104119
Lrlc222 nrlc222_1 nrlc222_2 4.34636154683e-06
Crlc222 nrlc222_2 rlc5 1.83294493157e-07
* RLC[224] rlc4-rlc7
Rrlc224 rlc4 nrlc224_1 4215.36660374
Lrlc224 nrlc224_1 nrlc224_2 1
Crlc224 nrlc224_2 rlc7 6.25297639974e-11
* RLC[225] rlc4-rlc8
Rrlc225 rlc4 nrlc225_1 98.7339912186
Lrlc225 nrlc225_1 nrlc225_2 2.88968532029e-07
Crlc225 nrlc225_2 rlc8 6.4748486596e-09
* RLC[229] rlc4-rlc12
Rrlc229 rlc4 nrlc229_1 16.7909384693
Lrlc229 nrlc229_1 nrlc229_2 0.0986460592232
Crlc229 nrlc229_2 rlc12 3.88765835439e-07
* RLC[232] rlc4-rlc15
Rrlc232 rlc4 nrlc232_1 7.20602586465
Lrlc232 nrlc232_1 nrlc232_2 0.944509651689
Crlc232 nrlc232_2 rlc15 2.02102766098e-05
* RLC[233] rlc4-GND
Rrlc233 rlc4 nrlc233_1 295.426252713
Lrlc233 nrlc233_1 nrlc233_2 2.05705264891e-12
Crlc233 nrlc233_2 GND 1.81599605331e-12
* RLC[235] rlc5-rlc7
Rrlc235 rlc5 nrlc235_1 75.1662315132
Lrlc235 nrlc235_1 nrlc235_2 0.985618605212
Crlc235 nrlc235_2 rlc7 1.93829925548e-07
* RLC[236] rlc5-rlc8
Rrlc236 rlc5 nrlc236_1 224.46273774
Lrlc236 nrlc236_1 nrlc236_2 0.999149420348
Crlc236 nrlc236_2 rlc8 2.20343082152e-08
* RLC[237] rlc5-rlc9
Rrlc237 rlc5 nrlc237_1 0.769074111737
Lrlc237 nrlc237_1 nrlc237_2 0.53232749041
Crlc237 nrlc237_2 rlc9 0.001
* RLC[239] rlc5-rlc11
Rrlc239 rlc5 nrlc239_1 368.74825214
Lrlc239 nrlc239_1 nrlc239_2 0.963138445535
Crlc239 nrlc239_2 rlc11 7.87020905471e-09
* RLC[240] rlc5-rlc12
Rrlc240 rlc5 nrlc240_1 1.56047859165
Lrlc240 nrlc240_1 nrlc240_2 0.120537155875
Crlc240 nrlc240_2 rlc12 5.50000140731e-05
* RLC[241] rlc5-rlc13
Rrlc241 rlc5 nrlc241_1 339.3413603
Lrlc241 nrlc241_1 nrlc241_2 0.999998330759
Crlc241 nrlc241_2 rlc13 9.64901924785e-09
* RLC[242] rlc5-rlc14
Rrlc242 rlc5 nrlc242_1 248.73173996
Lrlc242 nrlc242_1 nrlc242_2 0.860755972435
Crlc242 nrlc242_2 rlc14 1.54587765443e-08
* RLC[243] rlc5-rlc15
Rrlc243 rlc5 nrlc243_1 0.01
Lrlc243 nrlc243_1 nrlc243_2 3.2960962256e-14
Crlc243 nrlc243_2 rlc15 6.04802081862e-09
* RLC[244] rlc5-GND
Rrlc244 rlc5 nrlc244_1 216.613930085
Lrlc244 nrlc244_1 nrlc244_2 3.30098318475e-08
Crlc244 nrlc244_2 GND 2.29921311406e-12
* RLC[245] rlc6-rlc7
Rrlc245 rlc6 nrlc245_1 3.87311502311
Lrlc245 nrlc245_1 nrlc245_2 0.406738130905
Crlc245 nrlc245_2 rlc7 3.01267018573e-05
* RLC[249] rlc6-rlc11
Rrlc249 rlc6 nrlc249_1 48.9875782665
Lrlc249 nrlc249_1 nrlc249_2 0.9999987842
Crlc249 nrlc249_2 rlc11 4.63004297271e-07
* RLC[251] rlc6-rlc13
Rrlc251 rlc6 nrlc251_1 4.05360053423
Lrlc251 nrlc251_1 nrlc251_2 0.033554185865
Crlc251 nrlc251_2 rlc13 2.27046326499e-06
* RLC[257] rlc7-rlc10
Rrlc257 rlc7 nrlc257_1 243.591936801
Lrlc257 nrlc257_1 nrlc257_2 0.723348916301
Crlc257 nrlc257_2 rlc10 1.35450155734e-08
* RLC[259] rlc7-rlc12
Rrlc259 rlc7 nrlc259_1 1723.19965422
Lrlc259 nrlc259_1 nrlc259_2 0.0032922357838
Crlc259 nrlc259_2 rlc12 1.23190501714e-12
* RLC[261] rlc7-rlc14
Rrlc261 rlc7 nrlc261_1 6.03588387029
Lrlc261 nrlc261_1 nrlc261_2 0.000524487222064
Crlc261 nrlc261_2 rlc14 1.59959726096e-08
* RLC[264] rlc8-rlc9
Rrlc264 rlc8 nrlc264_1 1.08793198788
Lrlc264 nrlc264_1 nrlc264_2 0.98766335204
Crlc264 nrlc264_2 rlc9 0.000927177613803
* RLC[267] rlc8-rlc12
Rrlc267 rlc8 nrlc267_1 297.109794703
Lrlc267 nrlc267_1 nrlc267_2 0.996542360932
Crlc267 nrlc267_2 rlc12 1.25435168175e-08
* RLC[268] rlc8-rlc13
Rrlc268 rlc8 nrlc268_1 1.02245229352
Lrlc268 nrlc268_1 nrlc268_2 0.940867823274
Crlc268 nrlc268_2 rlc13 0.001
* RLC[271] rlc8-GND
Rrlc271 rlc8 nrlc271_1 53916.5965401
Lrlc271 nrlc271_1 nrlc271_2 2.18419461547e-14
Crlc271 nrlc271_2 GND 5.364322038e-15
* RLC[274] rlc9-rlc12
Rrlc274 rlc9 nrlc274_1 1.05318226663
Lrlc274 nrlc274_1 nrlc274_2 0.998273598073
Crlc274 nrlc274_2 rlc12 0.001
* RLC[275] rlc9-rlc13
Rrlc275 rlc9 nrlc275_1 0.01
Lrlc275 nrlc275_1 nrlc275_2 2.81858627785e-10
Crlc275 nrlc275_2 rlc13 1.73085270457e-08
* RLC[276] rlc9-rlc14
Rrlc276 rlc9 nrlc276_1 86.6727404556
Lrlc276 nrlc276_1 nrlc276_2 0.991835585704
Crlc276 nrlc276_2 rlc14 1.4671905933e-07
* RLC[277] rlc9-rlc15
Rrlc277 rlc9 nrlc277_1 14.6716572524
Lrlc277 nrlc277_1 nrlc277_2 0.999950618411
Crlc277 nrlc277_2 rlc15 5.16152099573e-06
* RLC[279] rlc10-rlc11
Rrlc279 rlc10 nrlc279_1 201.653820229
Lrlc279 nrlc279_1 nrlc279_2 0.419703942688
Crlc279 nrlc279_2 rlc11 1.14679986124e-08
* RLC[282] rlc10-rlc14
Rrlc282 rlc10 nrlc282_1 153.06503676
Lrlc282 nrlc282_1 nrlc282_2 0.451307645807
Crlc282 nrlc282_2 rlc14 2.1403173966e-08
* RLC[283] rlc10-rlc15
Rrlc283 rlc10 nrlc283_1 28.9815327409
Lrlc283 nrlc283_1 nrlc283_2 0.878440303165
Crlc283 nrlc283_2 rlc15 1.16205596233e-06
* RLC[286] rlc11-rlc13
Rrlc286 rlc11 nrlc286_1 16.2019055058
Lrlc286 nrlc286_1 nrlc286_2 1
Crlc286 nrlc286_2 rlc13 4.23277614298e-06
* RLC[288] rlc11-rlc15
Rrlc288 rlc11 nrlc288_1 0.0276282267954
Lrlc288 nrlc288_1 nrlc288_2 1.22001868984e-15
Crlc288 nrlc288_2 rlc15 2.14925530937e-09
* RLC[290] rlc12-rlc13
Rrlc290 rlc12 nrlc290_1 355.209312733
Lrlc290 nrlc290_1 nrlc290_2 0.999905010133
Crlc290 nrlc290_2 rlc13 8.80536875396e-09
* RLC[295] rlc13-rlc15
Rrlc295 rlc13 nrlc295_1 16.2700171885
Lrlc295 nrlc295_1 nrlc295_2 1
Crlc295 nrlc295_2 rlc15 4.19741071717e-06
* RLC[297] rlc14-rlc15
Rrlc297 rlc14 nrlc297_1 317.984070941
Lrlc297 nrlc297_1 nrlc297_2 0.999997970687
Crlc297 nrlc297_2 rlc15 1.09886889229e-08
* DC[0] P1A-P2A
Rdc0 P1A ndc0_1 0.0859172326442
Ldc0 ndc0_1 P2A 1.03717994276e-07
* DC[1] P1A-P3A
Rdc1 P1A ndc1_1 3337603982.65
Ldc1 ndc1_1 P3A 1
* DC[17] P2A-P4B
Rdc17 P2A ndc17_1 1316554.4416
Ldc17 ndc17_1 P4B 1
* DC[23] P3A-P4A
Rdc23 P3A ndc23_1 0.129918322261
Ldc23 ndc23_1 P4A 1.87460086846e-07
* DC[24] P3A-P1B
Rdc24 P3A ndc24_1 2253561.6455
Ldc24 ndc24_1 P1B 1
* DC[42] P1B-P2B
Rdc42 P1B ndc42_1 0.013150779256
Ldc42 ndc42_1 P2B 8.31347634335e-07
* DC[43] P1B-P3B
Rdc43 P1B ndc43_1 0.01
Ldc43 ndc43_1 P3B 9.37480580933e-09
* DC[45] P1B-dc0
Rdc45 P1B ndc45_1 0.01
Ldc45 ndc45_1 dc0 6.17640170284e-07
* DC[46] P1B-dc1
Rdc46 P1B ndc46_1 0.01
Ldc46 ndc46_1 dc1 2.41967336588e-08
* DC[48] P1B-dc3
Rdc48 P1B ndc48_1 0.01
Ldc48 ndc48_1 dc3 2.40671583278e-08
* DC[50] P2B-P3B
Rdc50 P2B ndc50_1 0.01
Ldc50 ndc50_1 P3B 3.51027797749e-07
* DC[51] P2B-P4B
Rdc51 P2B ndc51_1 0.01
Ldc51 ndc51_1 P4B 6.43494276353e-09
* DC[52] P2B-dc0
Rdc52 P2B ndc52_1 0.01
Ldc52 ndc52_1 dc0 1.59154943092e-09
* DC[53] P2B-dc1
Rdc53 P2B ndc53_1 0.0112256749665
Ldc53 ndc53_1 dc1 1.29450391568e-06
* DC[54] P2B-dc2
Rdc54 P2B ndc54_1 0.01
Ldc54 ndc54_1 dc2 1.5187810519e-08
* DC[55] P2B-dc3
Rdc55 P2B ndc55_1 0.0138486622037
Ldc55 ndc55_1 dc3 1.52860754038e-06
* DC[57] P3B-P4B
Rdc57 P3B ndc57_1 0.01
Ldc57 ndc57_1 P4B 4.27546219299e-08
* DC[58] P3B-dc0
Rdc58 P3B ndc58_1 0.01
Ldc58 ndc58_1 dc0 1.11041860588e-06
* DC[59] P3B-dc1
Rdc59 P3B ndc59_1 0.01
Ldc59 ndc59_1 dc1 1.59154943092e-09
* DC[60] P3B-dc2
Rdc60 P3B ndc60_1 0.01
Ldc60 ndc60_1 dc2 4.71268158922e-07
* DC[61] P3B-dc3
Rdc61 P3B ndc61_1 0.01
Ldc61 ndc61_1 dc3 1.59154943092e-09
* DC[63] P4B-dc0
Rdc63 P4B ndc63_1 0.01
Ldc63 ndc63_1 dc0 1.1854807224e-08
* DC[64] P4B-dc1
Rdc64 P4B ndc64_1 0.01
Ldc64 ndc64_1 dc1 2.32830784348e-07
* DC[65] P4B-dc2
Rdc65 P4B ndc65_1 0.01
Ldc65 ndc65_1 dc2 1.59154943092e-09
* DC[66] P4B-dc3
Rdc66 P4B ndc66_1 0.01
Ldc66 ndc66_1 dc3 2.33849614036e-07
* DC[69] dc0-dc2
Rdc69 dc0 ndc69_1 0.01
Ldc69 ndc69_1 dc2 1.81534422698e-07
* ---- leaks
Rleak_P1A P1A GND 1e+12
Rleak_P1B P1B GND 1e+12
Rleak_P2A P2A GND 1e+12
Rleak_P2B P2B GND 1e+12
Rleak_P3A P3A GND 1e+12
Rleak_P3B P3B GND 1e+12
Rleak_P4A P4A GND 1e+12
Rleak_P4B P4B GND 1e+12
Rleak_dc0 dc0 GND 1e+12
Rleak_dc1 dc1 GND 1e+12
Rleak_dc2 dc2 GND 1e+12
Rleak_dc3 dc3 GND 1e+12
Rleak_rlc0 rlc0 GND 1e+12
Rleak_rlc1 rlc1 GND 1e+12
Rleak_rlc10 rlc10 GND 1e+12
Rleak_rlc11 rlc11 GND 1e+12
Rleak_rlc12 rlc12 GND 1e+12
Rleak_rlc13 rlc13 GND 1e+12
Rleak_rlc14 rlc14 GND 1e+12
Rleak_rlc15 rlc15 GND 1e+12
Rleak_rlc2 rlc2 GND 1e+12
Rleak_rlc3 rlc3 GND 1e+12
Rleak_rlc4 rlc4 GND 1e+12
Rleak_rlc5 rlc5 GND 1e+12
Rleak_rlc6 rlc6 GND 1e+12
Rleak_rlc7 rlc7 GND 1e+12
Rleak_rlc8 rlc8 GND 1e+12
Rleak_rlc9 rlc9 GND 1e+12
.ends fitted
