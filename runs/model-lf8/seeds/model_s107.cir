* fitted: 8-port fitted model, reference z0 = 50 Ohm
* every pin is a port against GND
.subckt fitted P1A P1B P2A P2B P3A P3B P4A P4B GND
* ---- branches
* RLC[0] P1A-P2A
Rrlc0 P1A nrlc0_1 0.142786683086
Lrlc0 nrlc0_1 nrlc0_2 1.21806799573e-07
Crlc0 nrlc0_2 P2A 0.00011346922058
* RLC[1] P1A-P3A
Rrlc1 P1A nrlc1_1 73531661686.1
Lrlc1 nrlc1_1 nrlc1_2 3.42636792641e-08
Crlc1 nrlc1_2 P3A 2.25003479631e-13
* RLC[2] P1A-P4A
Rrlc2 P1A nrlc2_1 1561.72076496
Lrlc2 nrlc2_1 nrlc2_2 1
Crlc2 nrlc2_2 P4A 0.001
* RLC[4] P1A-P2B
Rrlc4 P1A nrlc4_1 8.25087691222
Lrlc4 nrlc4_1 nrlc4_2 1.98550869891e-15
Crlc4 nrlc4_2 P2B 6.73399132593e-05
* RLC[6] P1A-P4B
Rrlc6 P1A nrlc6_1 0.117913205306
Lrlc6 nrlc6_1 nrlc6_2 7.22158445458e-07
Crlc6 nrlc6_2 P4B 7.57179074791e-05
* RLC[9] P1A-rlc2
Rrlc9 P1A nrlc9_1 379884.980621
Lrlc9 nrlc9_1 nrlc9_2 1
Crlc9 nrlc9_2 rlc2 7.6993354887e-15
* RLC[10] P1A-rlc3
Rrlc10 P1A nrlc10_1 192397.042601
Lrlc10 nrlc10_1 nrlc10_2 1
Crlc10 nrlc10_2 rlc3 3.00165452986e-14
* RLC[11] P1A-rlc4
Rrlc11 P1A nrlc11_1 180778.52796
Lrlc11 nrlc11_1 nrlc11_2 1
Crlc11 nrlc11_2 rlc4 3.39988164727e-14
* RLC[13] P1A-rlc6
Rrlc13 P1A nrlc13_1 0.0814582353491
Lrlc13 nrlc13_1 nrlc13_2 8.67990271766e-08
Crlc13 nrlc13_2 rlc6 0.000714252321877
* RLC[16] P1A-rlc9
Rrlc16 P1A nrlc16_1 292672030634
Lrlc16 nrlc16_1 nrlc16_2 0.999973279042
Crlc16 nrlc16_2 rlc9 4.21291578803e-05
* RLC[20] P1A-rlc13
Rrlc20 P1A nrlc20_1 341058.846627
Lrlc20 nrlc20_1 nrlc20_2 1
Crlc20 nrlc20_2 rlc13 9.55209982538e-15
* RLC[23] P1A-GND
Rrlc23 P1A nrlc23_1 90527.6729218
Lrlc23 nrlc23_1 nrlc23_2 1
Crlc23 nrlc23_2 GND 1.35579733912e-13
* RLC[25] P2A-P4A
Rrlc25 P2A nrlc25_1 14.7129505581
Lrlc25 nrlc25_1 nrlc25_2 0.000163566116205
Crlc25 nrlc25_2 P4A 3.1246722968e-06
* RLC[26] P2A-P1B
Rrlc26 P2A nrlc26_1 254.757959317
Lrlc26 nrlc26_1 nrlc26_2 1.30831779095e-13
Crlc26 nrlc26_2 P1B 0.001
* RLC[27] P2A-P2B
Rrlc27 P2A nrlc27_1 0.194968143869
Lrlc27 nrlc27_1 nrlc27_2 1.30473501808e-07
Crlc27 nrlc27_2 P2B 0.000221369407186
* RLC[28] P2A-P3B
Rrlc28 P2A nrlc28_1 0.347382523831
Lrlc28 nrlc28_1 nrlc28_2 1.66821954009e-08
Crlc28 nrlc28_2 P3B 1.53601254315e-10
* RLC[29] P2A-P4B
Rrlc29 P2A nrlc29_1 0.224162028582
Lrlc29 nrlc29_1 nrlc29_2 9.74328629102e-07
Crlc29 nrlc29_2 P4B 0.000211529991373
* RLC[30] P2A-rlc0
Rrlc30 P2A nrlc30_1 320857.3207
Lrlc30 nrlc30_1 nrlc30_2 1
Crlc30 nrlc30_2 rlc0 1.07927864814e-14
* RLC[32] P2A-rlc2
Rrlc32 P2A nrlc32_1 0.169807090153
Lrlc32 nrlc32_1 nrlc32_2 2.5369364961e-13
Crlc32 nrlc32_2 rlc2 9.77587066024e-15
* RLC[34] P2A-rlc4
Rrlc34 P2A nrlc34_1 131605.590386
Lrlc34 nrlc34_1 nrlc34_2 1
Crlc34 nrlc34_2 rlc4 6.41517953465e-14
* RLC[36] P2A-rlc6
Rrlc36 P2A nrlc36_1 0.0142146712347
Lrlc36 nrlc36_1 nrlc36_2 1.92303442729e-07
Crlc36 nrlc36_2 rlc6 0.000207754231278
* RLC[37] P2A-rlc7
Rrlc37 P2A nrlc37_1 242807.099033
Lrlc37 nrlc37_1 nrlc37_2 1
Crlc37 nrlc37_2 rlc7 1.88466745093e-14
* RLC[39] P2A-rlc9
Rrlc39 P2A nrlc39_1 379720.120534
Lrlc39 nrlc39_1 nrlc39_2 1
Crlc39 nrlc39_2 rlc9 7.70602245941e-15
* RLC[40] P2A-rlc10
Rrlc40 P2A nrlc40_1 155307.217763
Lrlc40 nrlc40_1 nrlc40_2 1
Crlc40 nrlc40_2 rlc10 4.60653326086e-14
* RLC[46] P2A-GND
Rrlc46 P2A nrlc46_1 4181.51789419
Lrlc46 nrlc46_1 nrlc46_2 0.000234861815322
Crlc46 nrlc46_2 GND 1.49245754087e-14
* RLC[48] P3A-P1B
Rrlc48 P3A nrlc48_1 0.407399114241
Lrlc48 nrlc48_1 nrlc48_2 3.8515703553e-06
Crlc48 nrlc48_2 P1B 0.000121272577312
* RLC[49] P3A-P2B
Rrlc49 P3A nrlc49_1 244.986612224
Lrlc49 nrlc49_1 nrlc49_2 2.41051977363e-05
Crlc49 nrlc49_2 P2B 0.001
* RLC[50] P3A-P3B
Rrlc50 P3A nrlc50_1 0.242722753073
Lrlc50 nrlc50_1 nrlc50_2 1.95641086515e-07
Crlc50 nrlc50_2 P3B 0.000161708077157
* RLC[51] P3A-P4B
Rrlc51 P3A nrlc51_1 0.273137348868
Lrlc51 nrlc51_1 nrlc51_2 1.52832423109e-07
Crlc51 nrlc51_2 P4B 5.48801148734e-05
* RLC[52] P3A-rlc0
Rrlc52 P3A nrlc52_1 148196.528355
Lrlc52 nrlc52_1 nrlc52_2 1
Crlc52 nrlc52_2 rlc0 5.0591951342e-14
* RLC[54] P3A-rlc2
Rrlc54 P3A nrlc54_1 155344.471838
Lrlc54 nrlc54_1 nrlc54_2 1
Crlc54 nrlc54_2 rlc2 4.6043240859e-14
* RLC[55] P3A-rlc3
Rrlc55 P3A nrlc55_1 303850.53334
Lrlc55 nrlc55_1 nrlc55_2 1
Crlc55 nrlc55_2 rlc3 1.20347614046e-14
* RLC[58] P3A-rlc6
Rrlc58 P3A nrlc58_1 0.24060002673
Lrlc58 nrlc58_1 nrlc58_2 8.52491769697e-07
Crlc58 nrlc58_2 rlc6 2.42435451168e-05
* RLC[60] P3A-rlc8
Rrlc60 P3A nrlc60_1 29310.5817738
Lrlc60 nrlc60_1 nrlc60_2 0.00253549078921
Crlc60 nrlc60_2 rlc8 3.27922072762e-15
* RLC[61] P3A-rlc9
Rrlc61 P3A nrlc61_1 271526.873967
Lrlc61 nrlc61_1 nrlc61_2 1
Crlc61 nrlc61_2 rlc9 1.5070645393e-14
* RLC[63] P3A-rlc11
Rrlc63 P3A nrlc63_1 4.33490146937e+12
Lrlc63 nrlc63_1 nrlc63_2 0.999557194859
Crlc63 nrlc63_2 rlc11 4.28774348008e-05
* RLC[64] P3A-rlc12
Rrlc64 P3A nrlc64_1 100757.924999
Lrlc64 nrlc64_1 nrlc64_2 1
Crlc64 nrlc64_2 rlc12 1.09445789989e-13
* RLC[66] P3A-rlc14
Rrlc66 P3A nrlc66_1 137571.871397
Lrlc66 nrlc66_1 nrlc66_2 1
Crlc66 nrlc66_2 rlc14 5.87081236765e-14
* RLC[70] P4A-P2B
Rrlc70 P4A nrlc70_1 0.392806028367
Lrlc70 nrlc70_1 nrlc70_2 2.63768925768e-06
Crlc70 nrlc70_2 P2B 0.000122283463693
* RLC[71] P4A-P3B
Rrlc71 P4A nrlc71_1 124.892055033
Lrlc71 nrlc71_1 nrlc71_2 4.41756171339e-10
Crlc71 nrlc71_2 P3B 0.001
* RLC[72] P4A-P4B
Rrlc72 P4A nrlc72_1 0.187171214905
Lrlc72 nrlc72_1 nrlc72_2 1.7807175289e-07
Crlc72 nrlc72_2 P4B 0.000169634443256
* RLC[76] P4A-rlc3
Rrlc76 P4A nrlc76_1 3225.86422812
Lrlc76 nrlc76_1 nrlc76_2 6.61185526422e-12
Crlc76 nrlc76_2 rlc3 1.48674659206e-14
* RLC[79] P4A-rlc6
Rrlc79 P4A nrlc79_1 0.01
Lrlc79 nrlc79_1 nrlc79_2 7.76950533942e-07
Crlc79 nrlc79_2 rlc6 3.05025285038e-05
* RLC[84] P4A-rlc11
Rrlc84 P4A nrlc84_1 232004.266185
Lrlc84 nrlc84_1 nrlc84_2 1
Crlc84 nrlc84_2 rlc11 2.06426547339e-14
* RLC[85] P4A-rlc12
Rrlc85 P4A nrlc85_1 100757.927154
Lrlc85 nrlc85_1 nrlc85_2 1
Crlc85 nrlc85_2 rlc12 1.09445785307e-13
* RLC[86] P4A-rlc13
Rrlc86 P4A nrlc86_1 4.88966107023e+12
Lrlc86 nrlc86_1 nrlc86_2 0.999992008752
Crlc86 nrlc86_2 rlc13 5.32295977941e-06
* RLC[89] P4A-GND
Rrlc89 P4A nrlc89_1 271527.224587
Lrlc89 nrlc89_1 nrlc89_2 1
Crlc89 nrlc89_2 GND 1.50706064719e-14
* RLC[90] P1B-P2B
Rrlc90 P1B nrlc90_1 0.0458571808941
Lrlc90 nrlc90_1 nrlc90_2 8.57979230135e-06
Crlc90 nrlc90_2 P2B 0.001
* RLC[91] P1B-P3B
Rrlc91 P1B nrlc91_1 0.01
Lrlc91 nrlc91_1 nrlc91_2 1.15221213358e-08
Crlc91 nrlc91_2 P3B 0.001
* RLC[95] P1B-rlc2
Rrlc95 P1B nrlc95_1 242770.099594
Lrlc95 nrlc95_1 nrlc95_2 1
Crlc95 nrlc95_2 rlc2 1.88524196115e-14
* RLC[99] P1B-rlc6
Rrlc99 P1B nrlc99_1 0.01
Lrlc99 nrlc99_1 nrlc99_2 1.4527133765e-08
Crlc99 nrlc99_2 rlc6 0.001
* RLC[103] P1B-rlc10
Rrlc103 P1B nrlc103_1 341636.552384
Lrlc103 nrlc103_1 nrlc103_2 1
Crlc103 nrlc103_2 rlc10 9.51982203007e-15
* RLC[109] P1B-GND
Rrlc109 P1B nrlc109_1 534907.564182
Lrlc109 nrlc109_1 nrlc109_2 1
Crlc109 nrlc109_2 GND 3.88329167627e-15
* RLC[110] P2B-P3B
Rrlc110 P2B nrlc110_1 19.4703845731
Lrlc110 nrlc110_1 nrlc110_2 4.67355523238e-15
Crlc110 nrlc110_2 P3B 0.001
* RLC[112] P2B-rlc0
Rrlc112 P2B nrlc112_1 2.19177436462e+12
Lrlc112 nrlc112_1 nrlc112_2 0.00546376970738
Crlc112 nrlc112_2 rlc0 2.44575297163e-06
* RLC[115] P2B-rlc3
Rrlc115 P2B nrlc115_1 6.37900356503
Lrlc115 nrlc115_1 nrlc115_2 1.46139005661e-07
Crlc115 nrlc115_2 rlc3 3.99041393936e-12
* RLC[117] P2B-rlc5
Rrlc117 P2B nrlc117_1 244801.714988
Lrlc117 nrlc117_1 nrlc117_2 1
Crlc117 nrlc117_2 rlc5 1.85408046705e-14
* RLC[118] P2B-rlc6
Rrlc118 P2B nrlc118_1 0.0691927497557
Lrlc118 nrlc118_1 nrlc118_2 7.89781617454e-08
Crlc118 nrlc118_2 rlc6 0.000502879165534
* RLC[119] P2B-rlc7
Rrlc119 P2B nrlc119_1 341640.053869
Lrlc119 nrlc119_1 nrlc119_2 1
Crlc119 nrlc119_2 rlc7 9.5196268929e-15
* RLC[121] P2B-rlc9
Rrlc121 P2B nrlc121_1 425318.252019
Lrlc121 nrlc121_1 nrlc121_2 1
Crlc121 nrlc121_2 rlc9 6.14227773313e-15
* RLC[123] P2B-rlc11
Rrlc123 P2B nrlc123_1 285353.702589
Lrlc123 nrlc123_1 nrlc123_2 1
Crlc123 nrlc123_2 rlc11 1.36455318168e-14
* RLC[126] P2B-rlc14
Rrlc126 P2B nrlc126_1 216782.592861
Lrlc126 nrlc126_1 nrlc126_2 1
Crlc126 nrlc126_2 rlc14 2.36433318405e-14
* RLC[130] P3B-rlc0
Rrlc130 P3B nrlc130_1 120074.454647
Lrlc130 nrlc130_1 nrlc130_2 1
Crlc130 nrlc130_2 rlc0 7.70648335772e-14
* RLC[133] P3B-rlc3
Rrlc133 P3B nrlc133_1 172023.626782
Lrlc133 nrlc133_1 nrlc133_2 1
Crlc133 nrlc133_2 rlc3 3.7547522932e-14
* RLC[136] P3B-rlc6
Rrlc136 P3B nrlc136_1 0.0134609452167
Lrlc136 nrlc136_1 nrlc136_2 6.12918049343e-08
Crlc136 nrlc136_2 rlc6 0.001
* RLC[138] P3B-rlc8
Rrlc138 P3B nrlc138_1 303860.250105
Lrlc138 nrlc138_1 nrlc138_2 1
Crlc138 nrlc138_2 rlc8 1.20339917279e-14
* RLC[140] P3B-rlc10
Rrlc140 P3B nrlc140_1 155307.213725
Lrlc140 nrlc140_1 nrlc140_2 1
Crlc140 nrlc140_2 rlc10 4.60653350038e-14
* RLC[143] P3B-rlc13
Rrlc143 P3B nrlc143_1 600028.475451
Lrlc143 nrlc143_1 nrlc143_2 1
Crlc143 nrlc143_2 rlc13 3.08612681662e-15
* RLC[144] P3B-rlc14
Rrlc144 P3B nrlc144_1 341336.632774
Lrlc144 nrlc144_1 nrlc144_2 1
Crlc144 nrlc144_2 rlc14 9.53655879611e-15
* RLC[145] P3B-rlc15
Rrlc145 P3B nrlc145_1 303850.544679
Lrlc145 nrlc145_1 nrlc145_2 1
Crlc145 nrlc145_2 rlc15 1.20347605064e-14
* RLC[149] P4B-rlc2
Rrlc149 P4B nrlc149_1 2.03646819955
Lrlc149 nrlc149_1 nrlc149_2 1.53138325367e-10
Crlc149 nrlc149_2 rlc2 4.10285452682e-14
* RLC[151] P4B-rlc4
Rrlc151 P4B nrlc151_1 145574.933314
Lrlc151 nrlc151_1 nrlc151_2 1
Crlc151 nrlc151_2 rlc4 5.24305351957e-14
* RLC[154] P4B-rlc7
Rrlc154 P4B nrlc154_1 341640.051791
Lrlc154 nrlc154_1 nrlc154_2 1
Crlc154 nrlc154_2 rlc7 9.5196270087e-15
* RLC[155] P4B-rlc8
Rrlc155 P4B nrlc155_1 271532.597489
Lrlc155 nrlc155_1 nrlc155_2 1
Crlc155 nrlc155_2 rlc8 1.5070010064e-14
* RLC[157] P4B-rlc10
Rrlc157 P4B nrlc157_1 216759.997979
Lrlc157 nrlc157_1 nrlc157_2 1
Crlc157 nrlc157_2 rlc10 2.36482612197e-14
* RLC[162] P4B-rlc15
Rrlc162 P4B nrlc162_1 303850.542293
Lrlc162 nrlc162_1 nrlc162_2 1
Crlc162 nrlc162_2 rlc15 1.20347606954e-14
* RLC[164] rlc0-rlc1
Rrlc164 rlc0 nrlc164_1 5.3053897065
Lrlc164 nrlc164_1 nrlc164_2 1
Crlc164 nrlc164_2 rlc1 3.94750700804e-05
* RLC[166] rlc0-rlc3
Rrlc166 rlc0 nrlc166_1 9.97604622823
Lrlc166 nrlc166_1 nrlc166_2 1
Crlc166 nrlc166_2 rlc3 1.11645335888e-05
* RLC[168] rlc0-rlc5
Rrlc168 rlc0 nrlc168_1 24.223874133
Lrlc168 nrlc168_1 nrlc168_2 1
Crlc168 nrlc168_2 rlc5 1.89352170668e-06
* RLC[171] rlc0-rlc8
Rrlc171 rlc0 nrlc171_1 7.5516721066
Lrlc171 nrlc171_1 nrlc171_2 1
Crlc171 nrlc171_2 rlc8 1.94836913577e-05
* RLC[172] rlc0-rlc9
Rrlc172 rlc0 nrlc172_1 60.3821767759
Lrlc172 nrlc172_1 nrlc172_2 1
Crlc172 nrlc172_2 rlc9 3.04747365586e-07
* RLC[176] rlc0-rlc13
Rrlc176 rlc0 nrlc176_1 5.85206054469
Lrlc176 nrlc176_1 nrlc176_2 1
Crlc176 nrlc176_2 rlc13 3.24444091298e-05
* RLC[179] rlc0-GND
Rrlc179 rlc0 nrlc179_1 1.11811103206
Lrlc179 nrlc179_1 nrlc179_2 1
Crlc179 nrlc179_2 GND 0.000888766395543
* RLC[181] rlc1-rlc3
Rrlc181 rlc1 nrlc181_1 823.4366055
Lrlc181 nrlc181_1 nrlc181_2 0.847242829557
Crlc181 nrlc181_2 rlc3 1.38836946547e-09
* RLC[182] rlc1-rlc4
Rrlc182 rlc1 nrlc182_1 580.13062736
Lrlc182 nrlc182_1 nrlc182_2 1
Crlc182 nrlc182_2 rlc4 3.30145895413e-09
* RLC[183] rlc1-rlc5
Rrlc183 rlc1 nrlc183_1 1.05226912899
Lrlc183 nrlc183_1 nrlc183_2 5.21853052854e-05
Crlc183 nrlc183_2 rlc5 5.23663205821e-08
* RLC[189] rlc1-rlc11
Rrlc189 rlc1 nrlc189_1 79.8727684108
Lrlc189 nrlc189_1 nrlc189_2 1
Crlc189 nrlc189_2 rlc11 1.74164651722e-07
* RLC[193] rlc1-rlc15
Rrlc193 rlc1 nrlc193_1 0.182462260831
Lrlc193 nrlc193_1 nrlc193_2 0.0260806007404
Crlc193 nrlc193_2 rlc15 0.000870420233119
* RLC[195] rlc2-rlc3
Rrlc195 rlc2 nrlc195_1 0.0718771864532
Lrlc195 nrlc195_1 nrlc195_2 0.00464969693918
Crlc195 nrlc195_2 rlc3 0.001
* RLC[196] rlc2-rlc4
Rrlc196 rlc2 nrlc196_1 1.05409255339
Lrlc196 nrlc196_1 nrlc196_2 1
Crlc196 nrlc196_2 rlc4 0.001
* RLC[197] rlc2-rlc5
Rrlc197 rlc2 nrlc197_1 220.37725756
Lrlc197 nrlc197_1 nrlc197_2 0.292073087897
Crlc197 nrlc197_2 rlc5 6.68213867291e-09
* RLC[198] rlc2-rlc6
Rrlc198 rlc2 nrlc198_1 271651.21992
Lrlc198 nrlc198_1 nrlc198_2 1
Crlc198 nrlc198_2 rlc6 1.50568516404e-14
* RLC[199] rlc2-rlc7
Rrlc199 rlc2 nrlc199_1 57.691021495
Lrlc199 nrlc199_1 nrlc199_2 0.0311803996407
Crlc199 nrlc199_2 rlc7 1.04093284029e-08
* RLC[201] rlc2-rlc9
Rrlc201 rlc2 nrlc201_1 15786.6421123
Lrlc201 nrlc201_1 nrlc201_2 0.0006449539627
Crlc201 nrlc201_2 rlc9 2.87545568611e-15
* RLC[202] rlc2-rlc10
Rrlc202 rlc2 nrlc202_1 18.5139501655
Lrlc202 nrlc202_1 nrlc202_2 0.832613779331
Crlc202 nrlc202_2 rlc10 2.69900011921e-06
* RLC[207] rlc2-rlc15
Rrlc207 rlc2 nrlc207_1 12.2099404517
Lrlc207 nrlc207_1 nrlc207_2 0.00111249162056
Crlc207 nrlc207_2 rlc15 8.29138625563e-09
* RLC[210] rlc3-rlc5
Rrlc210 rlc3 nrlc210_1 2.34153115455
Lrlc210 nrlc210_1 nrlc210_2 0.418013101563
Crlc210 nrlc210_2 rlc5 8.4712500916e-05
* RLC[211] rlc3-rlc6
Rrlc211 rlc3 nrlc211_1 6535.79850672
Lrlc211 nrlc211_1 nrlc211_2 0.000742584976151
Crlc211 nrlc211_2 rlc6 1.93155171071e-14
* RLC[212] rlc3-rlc7
Rrlc212 rlc3 nrlc212_1 71.9850630174
Lrlc212 nrlc212_1 nrlc212_2 0.240577306826
Crlc212 nrlc212_2 rlc7 9.8613803117e-06
* RLC[213] rlc3-rlc8
Rrlc213 rlc3 nrlc213_1 18.4222313259
Lrlc213 nrlc213_1 nrlc213_2 0.000111544228481
Crlc213 nrlc213_2 rlc8 3.651910553e-10
* RLC[215] rlc3-rlc10
Rrlc215 rlc3 nrlc215_1 31.4906778594
Lrlc215 nrlc215_1 nrlc215_2 0.362231062599
Crlc215 nrlc215_2 rlc10 4.05862720345e-07
* RLC[216] rlc3-rlc11
Rrlc216 rlc3 nrlc216_1 1.54389880186
Lrlc216 nrlc216_1 nrlc216_2 1
Crlc216 nrlc216_2 rlc11 0.000510818758212
* RLC[217] rlc3-rlc12
Rrlc217 rlc3 nrlc217_1 0.487414203949
Lrlc217 nrlc217_1 nrlc217_2 0.0567291823888
Crlc217 nrlc217_2 rlc12 0.000265318573053
* RLC[220] rlc3-rlc15
Rrlc220 rlc3 nrlc220_1 0.01
Lrlc220 nrlc220_1 nrlc220_2 3.86931758049e-08
Crlc220 nrlc220_2 rlc15 1.67259725313e-06
* RLC[224] rlc4-rlc7
Rrlc224 rlc4 nrlc224_1 319.858825299
Lrlc224 nrlc224_1 nrlc224_2 1
Crlc224 nrlc224_2 rlc7 1.0860274806e-08
* RLC[226] rlc4-rlc9
Rrlc226 rlc4 nrlc226_1 35.9051807433
Lrlc226 nrlc226_1 nrlc226_2 1
Crlc226 nrlc226_2 rlc9 8.61872960903e-07
* RLC[227] rlc4-rlc10
Rrlc227 rlc4 nrlc227_1 15.7889350629
Lrlc227 nrlc227_1 nrlc227_2 1
Crlc227 nrlc227_2 rlc10 4.45709420515e-06
* RLC[228] rlc4-rlc11
Rrlc228 rlc4 nrlc228_1 18.0162627408
Lrlc228 nrlc228_1 nrlc228_2 1
Crlc228 nrlc228_2 rlc11 3.42316692288e-06
* RLC[229] rlc4-rlc12
Rrlc229 rlc4 nrlc229_1 5.17324315766
Lrlc229 nrlc229_1 nrlc229_2 1
Crlc229 nrlc229_2 rlc12 4.15175489658e-05
* RLC[231] rlc4-rlc14
Rrlc231 rlc4 nrlc231_1 4.17097959924
Lrlc231 nrlc231_1 nrlc231_2 1
Crlc231 nrlc231_2 rlc14 6.38677121441e-05
* RLC[232] rlc4-rlc15
Rrlc232 rlc4 nrlc232_1 6.19628827968
Lrlc232 nrlc232_1 nrlc232_2 1
Crlc232 nrlc232_2 rlc15 2.89397157241e-05
* RLC[233] rlc4-GND
Rrlc233 rlc4 nrlc233_1 23.5837795301
Lrlc233 nrlc233_1 nrlc233_2 1
Crlc233 nrlc233_2 GND 1.99770187879e-06
* RLC[234] rlc5-rlc6
Rrlc234 rlc5 nrlc234_1 173529.529957
Lrlc234 nrlc234_1 nrlc234_2 1
Crlc234 nrlc234_2 rlc6 3.68986697716e-14
* RLC[237] rlc5-rlc9
Rrlc237 rlc5 nrlc237_1 534.588460127
Lrlc237 nrlc237_1 nrlc237_2 0.887541461093
Crlc237 nrlc237_2 rlc9 3.45069823206e-09
* RLC[242] rlc5-rlc14
Rrlc242 rlc5 nrlc242_1 336.039293989
Lrlc242 nrlc242_1 nrlc242_2 6.56902161686e-07
Crlc242 nrlc242_2 rlc14 6.46365331273e-15
* RLC[243] rlc5-rlc15
Rrlc243 rlc5 nrlc243_1 210.879559378
Lrlc243 nrlc243_1 nrlc243_2 0.122499189074
Crlc243 nrlc243_2 rlc15 3.06070683481e-09
* RLC[244] rlc5-GND
Rrlc244 rlc5 nrlc244_1 17.0036913013
Lrlc244 nrlc244_1 nrlc244_2 0.932238700806
Crlc244 nrlc244_2 GND 3.58259895668e-06
* RLC[245] rlc6-rlc7
Rrlc245 rlc6 nrlc245_1 128.711725931
Lrlc245 nrlc245_1 nrlc245_2 5.24392416354e-07
Crlc245 nrlc245_2 rlc7 3.51704289472e-14
* RLC[246] rlc6-rlc8
Rrlc246 rlc6 nrlc246_1 444.589607451
Lrlc246 nrlc246_1 nrlc246_2 2.62408384413e-05
Crlc246 nrlc246_2 rlc8 1.47508343101e-13
* RLC[247] rlc6-rlc9
Rrlc247 rlc6 nrlc247_1 341058.794587
Lrlc247 nrlc247_1 nrlc247_2 1
Crlc247 nrlc247_2 rlc9 9.55210274036e-15
* RLC[250] rlc6-rlc12
Rrlc250 rlc6 nrlc250_1 192252.164876
Lrlc250 nrlc250_1 nrlc250_2 1
Crlc250 nrlc250_2 rlc12 3.00618021866e-14
* RLC[251] rlc6-rlc13
Rrlc251 rlc6 nrlc251_1 476888.728872
Lrlc251 nrlc251_1 nrlc251_2 1
Crlc251 nrlc251_2 rlc13 4.88566150497e-15
* RLC[252] rlc6-rlc14
Rrlc252 rlc6 nrlc252_1 111211.337659
Lrlc252 nrlc252_1 nrlc252_2 1
Crlc252 nrlc252_2 rlc14 8.98378524199e-14
* RLC[253] rlc6-rlc15
Rrlc253 rlc6 nrlc253_1 341058.71008
Lrlc253 nrlc253_1 nrlc253_2 1
Crlc253 nrlc253_2 rlc15 9.55210747395e-15
* RLC[254] rlc6-GND
Rrlc254 rlc6 nrlc254_1 242668.999468
Lrlc254 nrlc254_1 nrlc254_2 1
Crlc254 nrlc254_2 GND 1.88681313755e-14
* RLC[255] rlc7-rlc8
Rrlc255 rlc7 nrlc255_1 24.0706053848
Lrlc255 nrlc255_1 nrlc255_2 0.0474708296222
Crlc255 nrlc255_2 rlc8 9.10353960841e-08
* RLC[257] rlc7-rlc10
Rrlc257 rlc7 nrlc257_1 3.04783445883
Lrlc257 nrlc257_1 nrlc257_2 8.05137636889e-07
Crlc257 nrlc257_2 rlc10 9.63041205028e-11
* RLC[258] rlc7-rlc11
Rrlc258 rlc7 nrlc258_1 1.07626376441
Lrlc258 nrlc258_1 nrlc258_2 1
Crlc258 nrlc258_2 rlc11 0.000959224037007
* RLC[260] rlc7-rlc13
Rrlc260 rlc7 nrlc260_1 16.1744113835
Lrlc260 nrlc260_1 nrlc260_2 0.0184227323628
Crlc260 nrlc260_2 rlc13 7.82446340618e-08
* RLC[261] rlc7-rlc14
Rrlc261 rlc7 nrlc261_1 34.7824171713
Lrlc261 nrlc261_1 nrlc261_2 0.00515796306255
Crlc261 nrlc261_2 rlc14 4.73713977265e-09
* RLC[262] rlc7-rlc15
Rrlc262 rlc7 nrlc262_1 12.0315132699
Lrlc262 nrlc262_1 nrlc262_2 0.00383883844073
Crlc262 nrlc262_2 rlc15 2.94657036608e-08
* RLC[263] rlc7-GND
Rrlc263 rlc7 nrlc263_1 29.512095789
Lrlc263 nrlc263_1 nrlc263_2 0.131857226168
Crlc263 nrlc263_2 GND 1.68213684009e-07
* RLC[269] rlc8-rlc14
Rrlc269 rlc8 nrlc269_1 1.11321099631
Lrlc269 nrlc269_1 nrlc269_2 0.00122284639968
Crlc269 nrlc269_2 rlc14 1.09641362671e-06
* RLC[271] rlc8-GND
Rrlc271 rlc8 nrlc271_1 0.0201585589012
Lrlc271 nrlc271_1 nrlc271_2 6.01579828351e-13
Crlc271 nrlc271_2 GND 1.64487080408e-12
* RLC[272] rlc9-rlc10
Rrlc272 rlc9 nrlc272_1 15.400493089
Lrlc272 nrlc272_1 nrlc272_2 0.350756495448
Crlc272 nrlc272_2 rlc10 1.64321337187e-06
* RLC[273] rlc9-rlc11
Rrlc273 rlc9 nrlc273_1 45.959380437
Lrlc273 nrlc273_1 nrlc273_2 1
Crlc273 nrlc273_2 rlc11 5.26028360618e-07
* RLC[277] rlc9-rlc15
Rrlc277 rlc9 nrlc277_1 0.623006030854
Lrlc277 nrlc277_1 nrlc277_2 2.2790003765e-06
Crlc277 nrlc277_2 rlc15 6.52405158e-09
* RLC[279] rlc10-rlc11
Rrlc279 rlc10 nrlc279_1 14.0669946252
Lrlc279 nrlc279_1 nrlc279_2 1
Crlc279 nrlc279_2 rlc11 5.6150657693e-06
* RLC[280] rlc10-rlc12
Rrlc280 rlc10 nrlc280_1 0.290407125276
Lrlc280 nrlc280_1 nrlc280_2 0.00223562224488
Crlc280 nrlc280_2 rlc12 2.9453802969e-05
* RLC[284] rlc10-GND
Rrlc284 rlc10 nrlc284_1 370.417321729
Lrlc284 nrlc284_1 nrlc284_2 0.808271866097
Crlc284 nrlc284_2 GND 6.54534252151e-09
* RLC[287] rlc11-rlc14
Rrlc287 rlc11 nrlc287_1 403.668755935
Lrlc287 nrlc287_1 nrlc287_2 1
Crlc287 nrlc287_2 rlc14 6.81878847032e-09
* RLC[288] rlc11-rlc15
Rrlc288 rlc11 nrlc288_1 109.760998255
Lrlc288 nrlc288_1 nrlc288_2 1
Crlc288 nrlc288_2 rlc15 9.22277033845e-08
* RLC[290] rlc12-rlc13
Rrlc290 rlc12 nrlc290_1 2148021.99651
Lrlc290 nrlc290_1 nrlc290_2 0.265409056434
Crlc290 nrlc290_2 rlc13 6.39139678423e-17
* RLC[291] rlc12-rlc14
Rrlc291 rlc12 nrlc291_1 17.6009394871
Lrlc291 nrlc291_1 nrlc291_2 1
Crlc291 nrlc291_2 rlc14 9.87011626692e-06
* RLC[292] rlc12-rlc15
Rrlc292 rlc12 nrlc292_1 250.418271122
Lrlc292 nrlc292_1 nrlc292_2 0.000878421990197
Crlc292 nrlc292_2 rlc15 1.55642667027e-11
* RLC[294] rlc13-rlc14
Rrlc294 rlc13 nrlc294_1 2.83453188531
Lrlc294 nrlc294_1 nrlc294_2 0.0132605578897
Crlc294 nrlc294_2 rlc14 1.83381952746e-06
* RLC[295] rlc13-rlc15
Rrlc295 rlc13 nrlc295_1 0.179199612197
Lrlc295 nrlc295_1 nrlc295_2 7.02165715867e-07
Crlc295 nrlc295_2 rlc15 2.42953399507e-08
* RLC[296] rlc13-GND
Rrlc296 rlc13 nrlc296_1 0.01
Lrlc296 nrlc296_1 nrlc296_2 1.18573879335e-10
Crlc296 nrlc296_2 GND 8.45046118755e-08
* DC[0] P1A-P2A
Rdc0 P1A ndc0_1 0.0859026799871
Ldc0 ndc0_1 P2A 1.31419275537e-06
* DC[4] P1A-P2B
Rdc4 P1A ndc4_1 672431578.792
Ldc4 ndc4_1 P2B 1
* DC[23] P3A-P4A
Rdc23 P3A ndc23_1 0.129918600758
Ldc23 ndc23_1 P4A 1.62904402989e-07
* DC[25] P3A-P2B
Rdc25 P3A ndc25_1 98176883.2792
Ldc25 ndc25_1 P2B 1
* DC[33] P4A-P1B
Rdc33 P4A ndc33_1 295278035183
Ldc33 ndc33_1 P1B 1
* DC[42] P1B-P2B
Rdc42 P1B ndc42_1 0.0351499213624
Ldc42 ndc42_1 P2B 2.72989347217e-06
* DC[43] P1B-P3B
Rdc43 P1B ndc43_1 0.01
Ldc43 ndc43_1 P3B 8.20505583775e-09
* DC[44] P1B-P4B
Rdc44 P1B ndc44_1 206911837.72
Ldc44 ndc44_1 P4B 1
* DC[45] P1B-dc0
Rdc45 P1B ndc45_1 0.01
Ldc45 ndc45_1 dc0 7.95625805038e-07
* DC[46] P1B-dc1
Rdc46 P1B ndc46_1 0.01
Ldc46 ndc46_1 dc1 8.08848318846e-07
* DC[47] P1B-dc2
Rdc47 P1B ndc47_1 0.01
Ldc47 ndc47_1 dc2 2.73758061146e-08
* DC[48] P1B-dc3
Rdc48 P1B ndc48_1 0.01
Ldc48 ndc48_1 dc3 1.26154189944e-06
* DC[50] P2B-P3B
Rdc50 P2B ndc50_1 0.01
Ldc50 ndc50_1 P3B 4.13788369097e-07
* DC[51] P2B-P4B
Rdc51 P2B ndc51_1 0.01
Ldc51 ndc51_1 P4B 8.06085961604e-09
* DC[52] P2B-dc0
Rdc52 P2B ndc52_1 0.01
Ldc52 ndc52_1 dc0 1.59154943092e-09
* DC[53] P2B-dc1
Rdc53 P2B ndc53_1 0.01
Ldc53 ndc53_1 dc1 1.59154943092e-09
* DC[54] P2B-dc2
Rdc54 P2B ndc54_1 0.01
Ldc54 ndc54_1 dc2 1.42812377257e-06
* DC[55] P2B-dc3
Rdc55 P2B ndc55_1 0.01
Ldc55 ndc55_1 dc3 2.47549450054e-08
* DC[57] P3B-P4B
Rdc57 P3B ndc57_1 0.01
Ldc57 ndc57_1 P4B 4.28385645341e-08
* DC[60] P3B-dc2
Rdc60 P3B ndc60_1 0.01
Ldc60 ndc60_1 dc2 1.59154943092e-09
* DC[61] P3B-dc3
Rdc61 P3B ndc61_1 0.01
Ldc61 ndc61_1 dc3 2.50159150832e-07
* DC[63] P4B-dc0
Rdc63 P4B ndc63_1 0.01
Ldc63 ndc63_1 dc0 1.45930422392e-08
* DC[64] P4B-dc1
Rdc64 P4B ndc64_1 0.01
Ldc64 ndc64_1 dc1 1.50271043425e-08
* DC[65] P4B-dc2
Rdc65 P4B ndc65_1 0.01
Ldc65 ndc65_1 dc2 1.48250300952e-07
* DC[66] P4B-dc3
Rdc66 P4B ndc66_1 0.01
Ldc66 ndc66_1 dc3 1.59154943092e-09
* DC[73] dc1-dc3
Rdc73 dc1 ndc73_1 0.01
Ldc73 ndc73_1 dc3 2.40575554935e-07
* ---- leaks
Rleak_P1A P1A GND 1e+12
Rleak_P1B P1B GND 1e+12
Rleak_P2A P2A GND 1e+12
Rleak_P2B P2B GND 1e+12
Rleak_P3A P3A GND 1e+12
Rleak_P3B P3B GND 1e+12
Rleak_P4A P4A GND 1e+12
Rleak_P4B P4B GND 1e+12
Rleak_dc0 dc0 GND 1e+12
Rleak_dc1 dc1 GND 1e+12
Rleak_dc2 dc2 GND 1e+12
Rleak_dc3 dc3 GND 1e+12
Rleak_rlc0 rlc0 GND 1e+12
Rleak_rlc1 rlc1 GND 1e+12
Rleak_rlc10 rlc10 GND 1e+12
Rleak_rlc11 rlc11 GND 1e+12
Rleak_rlc12 rlc12 GND 1e+12
Rleak_rlc13 rlc13 GND 1e+12
Rleak_rlc14 rlc14 GND 1e+12
Rleak_rlc15 rlc15 GND 1e+12
Rleak_rlc2 rlc2 GND 1e+12
Rleak_rlc3 rlc3 GND 1e+12
Rleak_rlc4 rlc4 GND 1e+12
Rleak_rlc5 rlc5 GND 1e+12
Rleak_rlc6 rlc6 GND 1e+12
Rleak_rlc7 rlc7 GND 1e+12
Rleak_rlc8 rlc8 GND 1e+12
Rleak_rlc9 rlc9 GND 1e+12
.ends fitted
