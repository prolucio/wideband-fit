* fitted: 8-port fitted model, reference z0 = 50 Ohm
* every pin is a port against GND
.subckt fitted P1A P1B P2A P2B P3A P3B P4A P4B GND
* ---- branches
* RLC[1] P1A-P3A
Rrlc1 P1A nrlc1_1 623.42884353
Lrlc1 nrlc1_1 nrlc1_2 9.96404249983e-07
Crlc1 nrlc1_2 P3A 9.23431169357e-12
* RLC[2] P1A-P4A
Rrlc2 P1A nrlc2_1 2476.50260288
Lrlc2 nrlc2_1 nrlc2_2 3.09472215837e-05
Crlc2 nrlc2_2 P4A 1.35607556264e-11
* RLC[3] P1A-P1B
Rrlc3 P1A nrlc3_1 96.6741085873
Lrlc3 nrlc3_1 nrlc3_2 2.26716419181e-06
Crlc3 nrlc3_2 P1B 1.63492491432e-11
* RLC[4] P1A-P2B
Rrlc4 P1A nrlc4_1 250914.577894
Lrlc4 nrlc4_1 nrlc4_2 0.000604830193667
Crlc4 nrlc4_2 P2B 0.001
* RLC[5] P1A-P3B
Rrlc5 P1A nrlc5_1 319.081982536
Lrlc5 nrlc5_1 nrlc5_2 5.0904151399e-06
Crlc5 nrlc5_2 P3B 1.92588567536e-11
* RLC[6] P1A-P4B
Rrlc6 P1A nrlc6_1 3.49932847151
Lrlc6 nrlc6_1 nrlc6_2 1.79210204298e-07
Crlc6 nrlc6_2 P4B 1.62611331091e-11
* RLC[7] P1A-rlc0
Rrlc7 P1A nrlc7_1 1.30338590762e+12
Lrlc7 nrlc7_1 nrlc7_2 0.000206409129248
Crlc7 nrlc7_2 rlc0 3.65645408907e-07
* RLC[11] P1A-rlc4
Rrlc11 P1A nrlc11_1 809.140412636
Lrlc11 nrlc11_1 nrlc11_2 1.18421809903e-14
Crlc11 nrlc11_2 rlc4 5.59928051362e-13
* RLC[12] P1A-rlc5
Rrlc12 P1A nrlc12_1 11299.5769158
Lrlc12 nrlc12_1 nrlc12_2 0.00353814747487
Crlc12 nrlc12_2 rlc5 3.07899551335e-14
* RLC[14] P1A-rlc7
Rrlc14 P1A nrlc14_1 382335.995521
Lrlc14 nrlc14_1 nrlc14_2 1
Crlc14 nrlc14_2 rlc7 7.60093670795e-15
* RLC[15] P1A-rlc8
Rrlc15 P1A nrlc15_1 1.98724901806e+12
Lrlc15 nrlc15_1 nrlc15_2 1
Crlc15 nrlc15_2 rlc8 1.14554890054e-05
* RLC[19] P1A-rlc12
Rrlc19 P1A nrlc19_1 146872.434974
Lrlc19 nrlc19_1 nrlc19_2 1
Crlc19 nrlc19_2 rlc12 5.15082625229e-14
* RLC[22] P1A-rlc15
Rrlc22 P1A nrlc22_1 4.69822092067e+12
Lrlc22 nrlc22_1 nrlc22_2 0.969944104408
Crlc22 nrlc22_2 rlc15 3.88437512778e-05
* RLC[24] P2A-P3A
Rrlc24 P2A nrlc24_1 2360.29793477
Lrlc24 nrlc24_1 nrlc24_2 2.98601529852e-05
Crlc24 nrlc24_2 P3A 1.34123226666e-11
* RLC[25] P2A-P4A
Rrlc25 P2A nrlc25_1 541.129381287
Lrlc25 nrlc25_1 nrlc25_2 1.46231196523e-06
Crlc25 nrlc25_2 P4A 8.66476576175e-12
* RLC[26] P2A-P1B
Rrlc26 P2A nrlc26_1 35.4252569081
Lrlc26 nrlc26_1 nrlc26_2 3.53680734278e-15
Crlc26 nrlc26_2 P1B 1.79055037562e-11
* RLC[27] P2A-P2B
Rrlc27 P2A nrlc27_1 150.564452615
Lrlc27 nrlc27_1 nrlc27_2 3.63449920554e-06
Crlc27 nrlc27_2 P2B 1.59760148948e-11
* RLC[28] P2A-P3B
Rrlc28 P2A nrlc28_1 24.0382013502
Lrlc28 nrlc28_1 nrlc28_2 4.68389991523e-15
Crlc28 nrlc28_2 P3B 1.7047047645e-11
* RLC[29] P2A-P4B
Rrlc29 P2A nrlc29_1 350.940962125
Lrlc29 nrlc29_1 nrlc29_2 6.93320232637e-06
Crlc29 nrlc29_2 P4B 1.7886113358e-11
* RLC[35] P2A-rlc5
Rrlc35 P2A nrlc35_1 6.82145194945e+12
Lrlc35 nrlc35_1 nrlc35_2 0.945286039303
Crlc35 nrlc35_2 rlc5 4.2523010268e-06
* RLC[36] P2A-rlc6
Rrlc36 P2A nrlc36_1 88600.8469112
Lrlc36 nrlc36_1 nrlc36_2 1
Crlc36 nrlc36_2 rlc6 1.41540832004e-13
* RLC[37] P2A-rlc7
Rrlc37 P2A nrlc37_1 6871.07918595
Lrlc37 nrlc37_1 nrlc37_2 1.40899103135e-10
Crlc37 nrlc37_2 rlc7 4.75307558913e-14
* RLC[40] P2A-rlc10
Rrlc40 P2A nrlc40_1 5.19352131287e+12
Lrlc40 nrlc40_1 nrlc40_2 6.59827768705e-05
Crlc40 nrlc40_2 rlc10 2.66600876335e-08
* RLC[41] P2A-rlc11
Rrlc41 P2A nrlc41_1 7.0908169131e+12
Lrlc41 nrlc41_1 nrlc41_2 0.929754918931
Crlc41 nrlc41_2 rlc11 2.20697039056e-07
* RLC[48] P3A-P1B
Rrlc48 P3A nrlc48_1 589.370887041
Lrlc48 nrlc48_1 nrlc48_2 8.21567607076e-06
Crlc48 nrlc48_2 P1B 1.64862646746e-11
* RLC[49] P3A-P2B
Rrlc49 P3A nrlc49_1 5.18491891318
Lrlc49 nrlc49_1 nrlc49_2 2.94456621992e-07
Crlc49 nrlc49_2 P2B 1.21701205018e-11
* RLC[50] P3A-P3B
Rrlc50 P3A nrlc50_1 258.396628403
Lrlc50 nrlc50_1 nrlc50_2 4.76078304896e-06
Crlc50 nrlc50_2 P3B 1.46347996576e-11
* RLC[51] P3A-P4B
Rrlc51 P3A nrlc51_1 79.5832006374
Lrlc51 nrlc51_1 nrlc51_2 1.23358536052e-14
Crlc51 nrlc51_2 P4B 1.79550692513e-11
* RLC[60] P3A-rlc8
Rrlc60 P3A nrlc60_1 548.540850434
Lrlc60 nrlc60_1 nrlc60_2 2.29361767897e-06
Crlc60 nrlc60_2 rlc8 8.4695545009e-15
* RLC[61] P3A-rlc9
Rrlc61 P3A nrlc61_1 2217.74046842
Lrlc61 nrlc61_1 nrlc61_2 8.0645646759e-13
Crlc61 nrlc61_2 rlc9 6.55619244848e-14
* RLC[69] P4A-P1B
Rrlc69 P4A nrlc69_1 29.3271516922
Lrlc69 nrlc69_1 nrlc69_2 2.07401059388e-15
Crlc69 nrlc69_2 P1B 1.78611426313e-11
* RLC[70] P4A-P2B
Rrlc70 P4A nrlc70_1 583.134018955
Lrlc70 nrlc70_1 nrlc70_2 7.46035289848e-06
Crlc70 nrlc70_2 P2B 1.73264045432e-11
* RLC[71] P4A-P3B
Rrlc71 P4A nrlc71_1 115173.218614
Lrlc71 nrlc71_1 nrlc71_2 7.39839330365e-11
Crlc71 nrlc71_2 P3B 0.001
* RLC[72] P4A-P4B
Rrlc72 P4A nrlc72_1 184.01808036
Lrlc72 nrlc72_1 nrlc72_2 3.49661442183e-06
Crlc72 nrlc72_2 P4B 1.49196739288e-11
* RLC[73] P4A-rlc0
Rrlc73 P4A nrlc73_1 104588.869643
Lrlc73 nrlc73_1 nrlc73_2 0.00488298106246
Crlc73 nrlc73_2 rlc0 4.95988482669e-16
* RLC[87] P4A-rlc14
Rrlc87 P4A nrlc87_1 8510.33678939
Lrlc87 nrlc87_1 nrlc87_2 0.00133893943254
Crlc87 nrlc87_2 rlc14 2.05411582303e-14
* RLC[90] P1B-P2B
Rrlc90 P1B nrlc90_1 0.0461408403084
Lrlc90 nrlc90_1 nrlc90_2 8.10263472152e-06
Crlc90 nrlc90_2 P2B 0.001
* RLC[91] P1B-P3B
Rrlc91 P1B nrlc91_1 0.01
Lrlc91 nrlc91_1 nrlc91_2 1.09731377106e-08
Crlc91 nrlc91_2 P3B 0.001
* RLC[92] P1B-P4B
Rrlc92 P1B nrlc92_1 0.380640369943
Lrlc92 nrlc92_1 nrlc92_2 1.75982900916e-08
Crlc92 nrlc92_2 P4B 1.34957886802e-10
* RLC[93] P1B-rlc0
Rrlc93 P1B nrlc93_1 194351.253108
Lrlc93 nrlc93_1 nrlc93_2 1
Crlc93 nrlc93_2 rlc0 2.9415944689e-14
* RLC[96] P1B-rlc3
Rrlc96 P1B nrlc96_1 26248.7924281
Lrlc96 nrlc96_1 nrlc96_2 0.0115893284726
Crlc96 nrlc96_2 rlc3 1.86894751571e-14
* RLC[98] P1B-rlc5
Rrlc98 P1B nrlc98_1 216343.528481
Lrlc98 nrlc98_1 nrlc98_2 1
Crlc98 nrlc98_2 rlc5 2.37393964545e-14
* RLC[105] P1B-rlc12
Rrlc105 P1B nrlc105_1 423693.584322
Lrlc105 nrlc105_1 nrlc105_2 0.998907705207
Crlc105 nrlc105_2 rlc12 6.18271286992e-15
* RLC[111] P2B-P4B
Rrlc111 P2B nrlc111_1 0.01
Lrlc111 nrlc111_1 nrlc111_2 1.21917923829e-08
Crlc111 nrlc111_2 P4B 0.001
* RLC[112] P2B-rlc0
Rrlc112 P2B nrlc112_1 792279957508
Lrlc112 nrlc112_1 nrlc112_2 1.23371159477e-06
Crlc112 nrlc112_2 rlc0 2.79160535843e-05
* RLC[115] P2B-rlc3
Rrlc115 P2B nrlc115_1 176752.105514
Lrlc115 nrlc115_1 nrlc115_2 1
Crlc115 nrlc115_2 rlc3 3.55654492334e-14
* RLC[116] P2B-rlc4
Rrlc116 P2B nrlc116_1 0.01
Lrlc116 nrlc116_1 nrlc116_2 9.44244356199e-15
Crlc116 nrlc116_2 rlc4 4.33940773479e-12
* RLC[117] P2B-rlc5
Rrlc117 P2B nrlc117_1 0.903891295925
Lrlc117 nrlc117_1 nrlc117_2 6.48211446993e-11
Crlc117 nrlc117_2 rlc5 8.81539502147e-14
* RLC[120] P2B-rlc8
Rrlc120 P2B nrlc120_1 4.83248265598e+12
Lrlc120 nrlc120_1 nrlc120_2 7.7661065483e-08
Crlc120 nrlc120_2 rlc8 4.2407307511e-08
* RLC[124] P2B-rlc12
Rrlc124 P2B nrlc124_1 464474.912639
Lrlc124 nrlc124_1 nrlc124_2 0.818630143066
Crlc124 nrlc124_2 rlc12 4.55232596481e-15
* RLC[126] P2B-rlc14
Rrlc126 P2B nrlc126_1 340042.279062
Lrlc126 nrlc126_1 nrlc126_2 1
Crlc126 nrlc126_2 rlc14 9.60929782793e-15
* RLC[128] P2B-GND
Rrlc128 P2B nrlc128_1 303716.115128
Lrlc128 nrlc128_1 nrlc128_2 1
Crlc128 nrlc128_2 GND 1.20454164144e-14
* RLC[129] P3B-P4B
Rrlc129 P3B nrlc129_1 13972.8427689
Lrlc129 nrlc129_1 nrlc129_2 1
Crlc129 nrlc129_2 P4B 5.69099162253e-12
* RLC[131] P3B-rlc1
Rrlc131 P3B nrlc131_1 97174.1182465
Lrlc131 nrlc131_1 nrlc131_2 1
Crlc131 nrlc131_2 rlc1 1.17667431468e-13
* RLC[136] P3B-rlc6
Rrlc136 P3B nrlc136_1 489059.241071
Lrlc136 nrlc136_1 nrlc136_2 1
Crlc136 nrlc136_2 rlc6 4.64552232391e-15
* RLC[137] P3B-rlc7
Rrlc137 P3B nrlc137_1 270731.505875
Lrlc137 nrlc137_1 nrlc137_2 1
Crlc137 nrlc137_2 rlc7 1.51593260066e-14
* RLC[142] P3B-rlc12
Rrlc142 P3B nrlc142_1 23.4253741733
Lrlc142 nrlc142_1 nrlc142_2 2.78711200078e-06
Crlc142 nrlc142_2 rlc12 5.643374074e-12
* RLC[146] P3B-GND
Rrlc146 P3B nrlc146_1 4.82059855336e+12
Lrlc146 nrlc146_1 nrlc146_2 0.973939547029
Crlc146 nrlc146_2 GND 0.000718550194644
* RLC[147] P4B-rlc0
Rrlc147 P4B nrlc147_1 4.62119707909e+12
Lrlc147 nrlc147_1 nrlc147_2 0.98513094919
Crlc147 nrlc147_2 rlc0 1.63422290742e-06
* RLC[148] P4B-rlc1
Rrlc148 P4B nrlc148_1 5.94132482626e+12
Lrlc148 nrlc148_1 nrlc148_2 0.99999999998
Crlc148 nrlc148_2 rlc1 2.45557557336e-08
* RLC[149] P4B-rlc2
Rrlc149 P4B nrlc149_1 830.831149314
Lrlc149 nrlc149_1 nrlc149_2 4.61149019773e-05
Crlc149 nrlc149_2 rlc2 7.42289366371e-14
* RLC[157] P4B-rlc10
Rrlc157 P4B nrlc157_1 71.9961893657
Lrlc157 nrlc157_1 nrlc157_2 9.14181505313e-08
Crlc157 nrlc157_2 rlc10 1.95961565496e-14
* RLC[162] P4B-rlc15
Rrlc162 P4B nrlc162_1 4.79014799221e+12
Lrlc162 nrlc162_1 nrlc162_2 1.74702823439e-05
Crlc162 nrlc162_2 rlc15 5.10204197488e-08
* RLC[163] P4B-GND
Rrlc163 P4B nrlc163_1 382599.509549
Lrlc163 nrlc163_1 nrlc163_2 1
Crlc163 nrlc163_2 GND 7.5904700783e-15
* RLC[166] rlc0-rlc3
Rrlc166 rlc0 nrlc166_1 0.01
Lrlc166 nrlc166_1 nrlc166_2 3.80877557123e-09
Crlc166 nrlc166_2 rlc3 9.37384401471e-05
* RLC[167] rlc0-rlc4
Rrlc167 rlc0 nrlc167_1 0.247113131236
Lrlc167 nrlc167_1 nrlc167_2 1.14389592867e-06
Crlc167 nrlc167_2 rlc4 2.08138469729e-08
* RLC[177] rlc0-rlc14
Rrlc177 rlc0 nrlc177_1 0.0160980165493
Lrlc177 nrlc177_1 nrlc177_2 6.57378735658e-08
Crlc177 nrlc177_2 rlc14 2.8185672623e-07
* RLC[178] rlc0-rlc15
Rrlc178 rlc0 nrlc178_1 0.01
Lrlc178 nrlc178_1 nrlc178_2 4.21141321649e-09
Crlc178 nrlc178_2 rlc15 2.09476037663e-07
* RLC[187] rlc1-rlc9
Rrlc187 rlc1 nrlc187_1 0.0423649635751
Lrlc187 nrlc187_1 nrlc187_2 3.00437243089e-07
Crlc187 nrlc187_2 rlc9 6.53149043404e-07
* RLC[188] rlc1-rlc10
Rrlc188 rlc1 nrlc188_1 3110.24420657
Lrlc188 nrlc188_1 nrlc188_2 1
Crlc188 nrlc188_2 rlc10 1.14859920397e-10
* RLC[193] rlc1-rlc15
Rrlc193 rlc1 nrlc193_1 10.6916770138
Lrlc193 nrlc193_1 nrlc193_2 3.22320234334e-07
Crlc193 nrlc193_2 rlc15 3.13294953519e-12
* RLC[198] rlc2-rlc6
Rrlc198 rlc2 nrlc198_1 0.169407786397
Lrlc198 nrlc198_1 nrlc198_2 6.8033408626e-07
Crlc198 nrlc198_2 rlc6 2.63398311011e-08
* RLC[202] rlc2-rlc10
Rrlc202 rlc2 nrlc202_1 3.27102346367
Lrlc202 nrlc202_1 nrlc202_2 1
Crlc202 nrlc202_2 rlc10 0.000103846095394
* RLC[203] rlc2-rlc11
Rrlc203 rlc2 nrlc203_1 221870.250112
Lrlc203 nrlc203_1 nrlc203_2 0.144588894706
Crlc203 nrlc203_2 rlc11 0.000622286778159
* RLC[215] rlc3-rlc10
Rrlc215 rlc3 nrlc215_1 22.204481782
Lrlc215 nrlc215_1 nrlc215_2 1
Crlc215 nrlc215_2 rlc10 2.25359674561e-06
* RLC[219] rlc3-rlc14
Rrlc219 rlc3 nrlc219_1 0.447732265595
Lrlc219 nrlc219_1 nrlc219_2 1.89695472673e-06
Crlc219 nrlc219_2 rlc14 1.05142347961e-08
* RLC[221] rlc3-GND
Rrlc221 rlc3 nrlc221_1 0.01
Lrlc221 nrlc221_1 nrlc221_2 5.42040455959e-07
Crlc221 nrlc221_2 GND 0.000971400948738
* RLC[227] rlc4-rlc10
Rrlc227 rlc4 nrlc227_1 1.07891250298
Lrlc227 nrlc227_1 nrlc227_2 1
Crlc227 nrlc227_2 rlc10 0.00095452001338
* RLC[231] rlc4-rlc14
Rrlc231 rlc4 nrlc231_1 0.01
Lrlc231 nrlc231_1 nrlc231_2 4.50984037408e-09
Crlc231 nrlc231_2 rlc14 1.08724269424e-05
* RLC[232] rlc4-rlc15
Rrlc232 rlc4 nrlc232_1 0.0224708257971
Lrlc232 nrlc232_1 nrlc232_2 7.83304050752e-07
Crlc232 nrlc232_2 rlc15 1.7236528316e-06
* RLC[239] rlc5-rlc11
Rrlc239 rlc5 nrlc239_1 0.648625098579
Lrlc239 nrlc239_1 nrlc239_2 3.80323630758e-07
Crlc239 nrlc239_2 rlc11 1.63313952975e-07
* RLC[242] rlc5-rlc14
Rrlc242 rlc5 nrlc242_1 255.927759254
Lrlc242 nrlc242_1 nrlc242_2 0.00111121650531
Crlc242 nrlc242_2 rlc14 1.8850435387e-11
* RLC[245] rlc6-rlc7
Rrlc245 rlc6 nrlc245_1 5.05036232299
Lrlc245 nrlc245_1 nrlc245_2 1.06276786676e-05
Crlc245 nrlc245_2 rlc7 4.62967849381e-10
* RLC[248] rlc6-rlc10
Rrlc248 rlc6 nrlc248_1 1.08858642786
Lrlc248 nrlc248_1 nrlc248_2 1
Crlc248 nrlc248_2 rlc10 0.000937630357141
* RLC[254] rlc6-GND
Rrlc254 rlc6 nrlc254_1 371.938843087
Lrlc254 nrlc254_1 nrlc254_2 6.05012980167e-05
Crlc254 nrlc254_2 GND 4.8593604099e-13
* RLC[256] rlc7-rlc9
Rrlc256 rlc7 nrlc256_1 0.0212385303711
Lrlc256 nrlc256_1 nrlc256_2 0.00040596765509
Crlc256 nrlc256_2 rlc9 0.001
* RLC[259] rlc7-rlc12
Rrlc259 rlc7 nrlc259_1 3675.87814279
Lrlc259 nrlc259_1 nrlc259_2 0.000314494597738
Crlc259 nrlc259_2 rlc12 2.58611878268e-14
* RLC[263] rlc7-GND
Rrlc263 rlc7 nrlc263_1 2.26645870844
Lrlc263 nrlc263_1 nrlc263_2 8.06555286056e-10
Crlc263 nrlc263_2 GND 1.74460056945e-13
* RLC[265] rlc8-rlc10
Rrlc265 rlc8 nrlc265_1 1.88225171061
Lrlc265 nrlc265_1 nrlc265_2 1
Crlc265 nrlc265_2 rlc10 0.000313618800583
* RLC[271] rlc8-GND
Rrlc271 rlc8 nrlc271_1 1.02668914588
Lrlc271 nrlc271_1 nrlc271_2 0.000337167991268
Crlc271 nrlc271_2 GND 3.55406926697e-07
* RLC[272] rlc9-rlc10
Rrlc272 rlc9 nrlc272_1 84.0756478754
Lrlc272 nrlc272_1 nrlc272_2 1
Crlc272 nrlc272_2 rlc10 6.05638459738e-05
* RLC[279] rlc10-rlc11
Rrlc279 rlc10 nrlc279_1 1.07573877998
Lrlc279 nrlc279_1 nrlc279_2 1
Crlc279 nrlc279_2 rlc11 0.000960160510748
* RLC[282] rlc10-rlc14
Rrlc282 rlc10 nrlc282_1 8213.18735096
Lrlc282 nrlc282_1 nrlc282_2 0.00180314033546
Crlc282 nrlc282_2 rlc14 2.97004862649e-14
* RLC[283] rlc10-rlc15
Rrlc283 rlc10 nrlc283_1 31.1325232421
Lrlc283 nrlc283_1 nrlc283_2 1
Crlc283 nrlc283_2 rlc15 1.14638065441e-06
* RLC[284] rlc10-GND
Rrlc284 rlc10 nrlc284_1 1.43080387156
Lrlc284 nrlc284_1 nrlc284_2 1
Crlc284 nrlc284_2 GND 0.0005427468072
* RLC[299] rlc15-GND
Rrlc299 rlc15 nrlc299_1 3591.01480011
Lrlc299 nrlc299_1 nrlc299_2 0.000347531736805
Crlc299 nrlc299_2 GND 2.99445348484e-14
* DC[0] P1A-P2A
Rdc0 P1A ndc0_1 0.16857919646
Ldc0 ndc0_1 P2A 5.00402088996e-07
* DC[1] P1A-P3A
Rdc1 P1A ndc1_1 591145.966521
Ldc1 ndc1_1 P3A 0.0940838026607
* DC[2] P1A-P4A
Rdc2 P1A ndc2_1 627803.202433
Ldc2 ndc2_1 P4A 0.0999179829562
* DC[5] P1A-P3B
Rdc5 P1A ndc5_1 2112332.65769
Ldc5 ndc5_1 P3B 0.336188183925
* DC[6] P1A-P4B
Rdc6 P1A ndc6_1 3765246.36796
Ldc6 ndc6_1 P4B 0.599257571419
* DC[8] P1A-dc1
Rdc8 P1A ndc8_1 100344.241463
Ldc8 ndc8_1 dc1 0.0159702820396
* DC[12] P2A-P3A
Rdc12 P2A ndc12_1 627262.775351
Ldc12 ndc12_1 P3A 0.0998319713146
* DC[13] P2A-P4A
Rdc13 P2A ndc13_1 587512.176097
Ldc13 ndc13_1 P4A 0.0935054669525
* DC[18] P2A-dc0
Rdc18 P2A ndc18_1 216956.534899
Ldc18 ndc18_1 dc0 0.0345297049653
* DC[20] P2A-dc2
Rdc20 P2A ndc20_1 115173.438846
Ldc20 ndc20_1 dc2 0.0183304221052
* DC[23] P3A-P4A
Rdc23 P3A ndc23_1 0.252796046012
Ldc23 ndc23_1 P4A 4.79826172638e-07
* DC[25] P3A-P2B
Rdc25 P3A ndc25_1 442686.159542
Ldc25 ndc25_1 P2B 0.0704556905295
* DC[28] P3A-dc0
Rdc28 P3A ndc28_1 99067.3530138
Ldc28 ndc28_1 dc0 0.0157670589312
* DC[29] P3A-dc1
Rdc29 P3A ndc29_1 156484.463294
Ldc29 ndc29_1 dc1 0.0249052758502
* DC[30] P3A-dc2
Rdc30 P3A ndc30_1 357194.685777
Ldc30 ndc30_1 dc2 0.0568492998875
* DC[33] P4A-P1B
Rdc33 P4A ndc33_1 192546.819207
Ldc33 ndc33_1 P1B 0.0306447780534
* DC[34] P4A-P2B
Rdc34 P4A ndc34_1 187136.384291
Ldc34 ndc34_1 P2B 0.0297836805922
* DC[36] P4A-P4B
Rdc36 P4A ndc36_1 183353.113822
Ldc36 ndc36_1 P4B 0.029181554396
* DC[42] P1B-P2B
Rdc42 P1B ndc42_1 0.0151053070669
Ldc42 ndc42_1 P2B 9.49318183818e-07
* DC[43] P1B-P3B
Rdc43 P1B ndc43_1 0.01
Ldc43 ndc43_1 P3B 7.90209345463e-09
* DC[44] P1B-P4B
Rdc44 P1B ndc44_1 0.01
Ldc44 ndc44_1 P4B 6.79684261321e-07
* DC[45] P1B-dc0
Rdc45 P1B ndc45_1 0.01
Ldc45 ndc45_1 dc0 2.25139560283e-08
* DC[46] P1B-dc1
Rdc46 P1B ndc46_1 0.01
Ldc46 ndc46_1 dc1 1.12295880048e-07
* DC[47] P1B-dc2
Rdc47 P1B ndc47_1 0.01
Ldc47 ndc47_1 dc2 7.53049151884e-07
* DC[48] P1B-dc3
Rdc48 P1B ndc48_1 0.010180477596
Ldc48 ndc48_1 dc3 1.91416062895e-06
* DC[50] P2B-P3B
Rdc50 P2B ndc50_1 0.01
Ldc50 ndc50_1 P3B 4.06454284002e-07
* DC[51] P2B-P4B
Rdc51 P2B ndc51_1 0.01
Ldc51 ndc51_1 P4B 8.69836168563e-09
* DC[52] P2B-dc0
Rdc52 P2B ndc52_1 0.01
Ldc52 ndc52_1 dc0 1.31217141997e-06
* DC[53] P2B-dc1
Rdc53 P2B ndc53_1 0.0802861394551
Ldc53 ndc53_1 dc1 1.2777935956e-08
* DC[54] P2B-dc2
Rdc54 P2B ndc54_1 0.01
Ldc54 ndc54_1 dc2 1.59154943092e-09
* DC[55] P2B-dc3
Rdc55 P2B ndc55_1 0.01
Ldc55 ndc55_1 dc3 2.22549175864e-08
* DC[57] P3B-P4B
Rdc57 P3B ndc57_1 0.01
Ldc57 ndc57_1 P4B 3.67938032722e-08
* DC[58] P3B-dc0
Rdc58 P3B ndc58_1 0.01
Ldc58 ndc58_1 dc0 1.59154943092e-09
* DC[59] P3B-dc1
Rdc59 P3B ndc59_1 0.01
Ldc59 ndc59_1 dc1 4.55290165567e-07
* DC[60] P3B-dc2
Rdc60 P3B ndc60_1 0.01
Ldc60 ndc60_1 dc2 1.00393566415e-06
* DC[61] P3B-dc3
Rdc61 P3B ndc61_1 0.01
Ldc61 ndc61_1 dc3 2.83810846496e-07
* DC[63] P4B-dc0
Rdc63 P4B ndc63_1 0.01
Ldc63 ndc63_1 dc0 3.42021574761e-07
* DC[64] P4B-dc1
Rdc64 P4B ndc64_1 0.01
Ldc64 ndc64_1 dc1 3.52424524409e-07
* DC[65] P4B-dc2
Rdc65 P4B ndc65_1 0.01
Ldc65 ndc65_1 dc2 1.78092853305e-08
* DC[66] P4B-dc3
Rdc66 P4B ndc66_1 0.01
Ldc66 ndc66_1 dc3 1.59154943092e-09
* DC[69] dc0-dc2
Rdc69 dc0 ndc69_1 0.0100000019386
Ldc69 ndc69_1 dc2 0.999967350261
* DC[70] dc0-dc3
Rdc70 dc0 ndc70_1 0.01
Ldc70 ndc70_1 dc3 0.00194647407297
* DC[75] dc2-dc3
Rdc75 dc2 ndc75_1 0.01
Ldc75 ndc75_1 dc3 1.32651528797e-06
* ---- leaks
Rleak_P1A P1A GND 1e+12
Rleak_P1B P1B GND 1e+12
Rleak_P2A P2A GND 1e+12
Rleak_P2B P2B GND 1e+12
Rleak_P3A P3A GND 1e+12
Rleak_P3B P3B GND 1e+12
Rleak_P4A P4A GND 1e+12
Rleak_P4B P4B GND 1e+12
Rleak_dc0 dc0 GND 1e+12
Rleak_dc1 dc1 GND 1e+12
Rleak_dc2 dc2 GND 1e+12
Rleak_dc3 dc3 GND 1e+12
Rleak_rlc0 rlc0 GND 1e+12
Rleak_rlc1 rlc1 GND 1e+12
Rleak_rlc10 rlc10 GND 1e+12
Rleak_rlc11 rlc11 GND 1e+12
Rleak_rlc12 rlc12 GND 1e+12
Rleak_rlc14 rlc14 GND 1e+12
Rleak_rlc15 rlc15 GND 1e+12
Rleak_rlc2 rlc2 GND 1e+12
Rleak_rlc3 rlc3 GND 1e+12
Rleak_rlc4 rlc4 GND 1e+12
Rleak_rlc5 rlc5 GND 1e+12
Rleak_rlc6 rlc6 GND 1e+12
Rleak_rlc7 rlc7 GND 1e+12
Rleak_rlc8 rlc8 GND 1e+12
Rleak_rlc9 rlc9 GND 1e+12
.ends fitted
