* fitted: 8-port fitted model, reference z0 = 50 Ohm
* every pin is a port against GND
.subckt fitted P1A P1B P2A P2B P3A P3B P4A P4B GND
* ---- branches
* RLC[1] P1A-P3A
Rrlc1 P1A nrlc1_1 13.7537664825
Lrlc1 nrlc1_1 nrlc1_2 1.75606137014e-14
Crlc1 nrlc1_2 P3A 4.94472282576e-06
* RLC[2] P1A-P4A
Rrlc2 P1A nrlc2_1 39.4849252556
Lrlc2 nrlc2_1 nrlc2_2 1.62811518714e-05
Crlc2 nrlc2_2 P4A 1.06090167323e-05
* RLC[3] P1A-P1B
Rrlc3 P1A nrlc3_1 0.143030697232
Lrlc3 nrlc3_1 nrlc3_2 1.29331065813e-07
Crlc3 nrlc3_2 P1B 0.000257580065723
* RLC[4] P1A-P2B
Rrlc4 P1A nrlc4_1 1.97310588944
Lrlc4 nrlc4_1 nrlc4_2 8.48465293796e-16
Crlc4 nrlc4_2 P2B 0.000240406236539
* RLC[5] P1A-P3B
Rrlc5 P1A nrlc5_1 0.245955144317
Lrlc5 nrlc5_1 nrlc5_2 6.18939158861e-07
Crlc5 nrlc5_2 P3B 0.000205282560627
* RLC[6] P1A-P4B
Rrlc6 P1A nrlc6_1 5.12456011049
Lrlc6 nrlc6_1 nrlc6_2 2.43102889729e-13
Crlc6 nrlc6_2 P4B 0.000228195935326
* RLC[8] P1A-rlc1
Rrlc8 P1A nrlc8_1 2740.20395775
Lrlc8 nrlc8_1 nrlc8_2 2.82381955765e-07
Crlc8 nrlc8_2 rlc1 1.68070548246e-13
* RLC[12] P1A-rlc5
Rrlc12 P1A nrlc12_1 5.44500662563e+12
Lrlc12 nrlc12_1 nrlc12_2 0.999187704321
Crlc12 nrlc12_2 rlc5 3.47428698554e-06
* RLC[15] P1A-rlc8
Rrlc15 P1A nrlc15_1 6.75159988524e+12
Lrlc15 nrlc15_1 nrlc15_2 0.980971991613
Crlc15 nrlc15_2 rlc8 4.05340070359e-05
* RLC[16] P1A-rlc9
Rrlc16 P1A nrlc16_1 1.91003426259e+13
Lrlc16 nrlc16_1 nrlc16_2 0.997988685042
Crlc16 nrlc16_2 rlc9 5.5720882815e-06
* RLC[21] P1A-rlc14
Rrlc21 P1A nrlc21_1 2.39556322814e+13
Lrlc21 nrlc21_1 nrlc21_2 0.999025278437
Crlc21 nrlc21_2 rlc14 0.000352353007819
* RLC[23] P1A-GND
Rrlc23 P1A nrlc23_1 2.12016670381e+13
Lrlc23 nrlc23_1 nrlc23_2 0.992755718114
Crlc23 nrlc23_2 GND 9.32541329757e-09
* RLC[24] P2A-P3A
Rrlc24 P2A nrlc24_1 39.4908726205
Lrlc24 nrlc24_1 nrlc24_2 1.62820158028e-05
Crlc24 nrlc24_2 P3A 1.06106937992e-05
* RLC[25] P2A-P4A
Rrlc25 P2A nrlc25_1 13.4324389659
Lrlc25 nrlc25_1 nrlc25_2 1.26805782349e-14
Crlc25 nrlc25_2 P4A 4.94474584268e-06
* RLC[26] P2A-P1B
Rrlc26 P2A nrlc26_1 2.01035067312
Lrlc26 nrlc26_1 nrlc26_2 2.84467197321e-15
Crlc26 nrlc26_2 P1B 0.000243463623822
* RLC[27] P2A-P2B
Rrlc27 P2A nrlc27_1 0.144066830208
Lrlc27 nrlc27_1 nrlc27_2 1.2158474223e-07
Crlc27 nrlc27_2 P2B 0.000251329275722
* RLC[28] P2A-P3B
Rrlc28 P2A nrlc28_1 4.50217111484
Lrlc28 nrlc28_1 nrlc28_2 5.34389212911e-14
Crlc28 nrlc28_2 P3B 0.000222313740103
* RLC[29] P2A-P4B
Rrlc29 P2A nrlc29_1 0.224240966031
Lrlc29 nrlc29_1 nrlc29_2 9.65410360222e-07
Crlc29 nrlc29_2 P4B 0.000211530824293
* RLC[33] P2A-rlc3
Rrlc33 P2A nrlc33_1 1.17297700529e+13
Lrlc33 nrlc33_1 nrlc33_2 0.980700904684
Crlc33 nrlc33_2 rlc3 1.63896665299e-06
* RLC[46] P2A-GND
Rrlc46 P2A nrlc46_1 4.4421343721e+12
Lrlc46 nrlc46_1 nrlc46_2 0.952264104134
Crlc46 nrlc46_2 GND 0.000169875723609
* RLC[48] P3A-P1B
Rrlc48 P3A nrlc48_1 0.382747688416
Lrlc48 nrlc48_1 nrlc48_2 1.14062556837e-06
Crlc48 nrlc48_2 P1B 0.000128275940633
* RLC[49] P3A-P2B
Rrlc49 P3A nrlc49_1 0.376331973026
Lrlc49 nrlc49_1 nrlc49_2 1.84859992588e-08
Crlc49 nrlc49_2 P2B 1.45030113575e-10
* RLC[50] P3A-P3B
Rrlc50 P3A nrlc50_1 0.204075006778
Lrlc50 nrlc50_1 nrlc50_2 1.89313092003e-07
Crlc50 nrlc50_2 P3B 0.000168823727242
* RLC[51] P3A-P4B
Rrlc51 P3A nrlc51_1 3.24229099593
Lrlc51 nrlc51_1 nrlc51_2 9.79234697279e-14
Crlc51 nrlc51_2 P4B 8.76026609132e-05
* RLC[53] P3A-rlc1
Rrlc53 P3A nrlc53_1 204959.572682
Lrlc53 nrlc53_1 nrlc53_2 1
Crlc53 nrlc53_2 rlc1 2.64497198642e-14
* RLC[59] P3A-rlc7
Rrlc59 P3A nrlc59_1 3306.11009141
Lrlc59 nrlc59_1 nrlc59_2 8.90273175299e-05
Crlc59 nrlc59_2 rlc7 1.29847688241e-14
* RLC[60] P3A-rlc8
Rrlc60 P3A nrlc60_1 1.13371099724e+13
Lrlc60 nrlc60_1 nrlc60_2 0.982954442422
Crlc60 nrlc60_2 rlc8 4.52623643036e-05
* RLC[66] P3A-rlc14
Rrlc66 P3A nrlc66_1 7.72918787767e+12
Lrlc66 nrlc66_1 nrlc66_2 0.9940410905
Crlc66 nrlc66_2 rlc14 7.29993547808e-06
* RLC[69] P4A-P1B
Rrlc69 P4A nrlc69_1 7.7588621763
Lrlc69 nrlc69_1 nrlc69_2 6.73664667746e-15
Crlc69 nrlc69_2 P1B 7.93920640556e-05
* RLC[70] P4A-P2B
Rrlc70 P4A nrlc70_1 0.373540568535
Lrlc70 nrlc70_1 nrlc70_2 1.99739184824e-06
Crlc70 nrlc70_2 P2B 0.000126697792487
* RLC[71] P4A-P3B
Rrlc71 P4A nrlc71_1 3.01277460288
Lrlc71 nrlc71_1 nrlc71_2 1.41188539236e-15
Crlc71 nrlc71_2 P3B 0.000102015263309
* RLC[72] P4A-P4B
Rrlc72 P4A nrlc72_1 0.186995475596
Lrlc72 nrlc72_1 nrlc72_2 1.77489476189e-07
Crlc72 nrlc72_2 P4B 0.000170385561575
* RLC[76] P4A-rlc3
Rrlc76 P4A nrlc76_1 897579.897651
Lrlc76 nrlc76_1 nrlc76_2 1
Crlc76 nrlc76_2 rlc3 1.37914921188e-15
* RLC[78] P4A-rlc5
Rrlc78 P4A nrlc78_1 83.00227472
Lrlc78 nrlc78_1 nrlc78_2 3.09626660836e-08
Crlc78 nrlc78_2 rlc5 4.99362413692e-15
* RLC[80] P4A-rlc7
Rrlc80 P4A nrlc80_1 17128763969.5
Lrlc80 nrlc80_1 nrlc80_2 0.00650555144573
Crlc80 nrlc80_2 rlc7 3.09858434556e-06
* RLC[81] P4A-rlc8
Rrlc81 P4A nrlc81_1 498561.067384
Lrlc81 nrlc81_1 nrlc81_2 1
Crlc81 nrlc81_2 rlc8 4.4701363221e-15
* RLC[85] P4A-rlc12
Rrlc85 P4A nrlc85_1 2765.55602413
Lrlc85 nrlc85_1 nrlc85_2 1.0293303439e-10
Crlc85 nrlc85_2 rlc12 1.27710582583e-14
* RLC[89] P4A-GND
Rrlc89 P4A nrlc89_1 1.40627217211e+13
Lrlc89 nrlc89_1 nrlc89_2 0.00383736571265
Crlc89 nrlc89_2 GND 5.21112355969e-07
* RLC[90] P1B-P2B
Rrlc90 P1B nrlc90_1 0.0529925463944
Lrlc90 nrlc90_1 nrlc90_2 7.87978851525e-06
Crlc90 nrlc90_2 P2B 0.001
* RLC[91] P1B-P3B
Rrlc91 P1B nrlc91_1 0.01
Lrlc91 nrlc91_1 nrlc91_2 1.76162987866e-08
Crlc91 nrlc91_2 P3B 0.001
* RLC[92] P1B-P4B
Rrlc92 P1B nrlc92_1 0.0530632180954
Lrlc92 nrlc92_1 nrlc92_2 0.00253413460318
Crlc92 nrlc92_2 P4B 0.001
* RLC[98] P1B-rlc5
Rrlc98 P1B nrlc98_1 254986.963169
Lrlc98 nrlc98_1 nrlc98_2 0.0491095898938
Crlc98 nrlc98_2 rlc5 8.39243226406e-16
* RLC[101] P1B-rlc8
Rrlc101 P1B nrlc101_1 354643.195968
Lrlc101 nrlc101_1 nrlc101_2 1
Crlc101 nrlc101_2 rlc8 8.83434237646e-15
* RLC[103] P1B-rlc10
Rrlc103 P1B nrlc103_1 313.083371534
Lrlc103 nrlc103_1 nrlc103_2 1.32533691601e-10
Crlc103 nrlc103_2 rlc10 1.08880200379e-13
* RLC[107] P1B-rlc14
Rrlc107 P1B nrlc107_1 2.58281831586e+13
Lrlc107 nrlc107_1 nrlc107_2 0.44343588041
Crlc107 nrlc107_2 rlc14 1.5175072818e-05
* RLC[111] P2B-P4B
Rrlc111 P2B nrlc111_1 0.01
Lrlc111 nrlc111_1 nrlc111_2 1.19359089182e-08
Crlc111 nrlc111_2 P4B 0.001
* RLC[115] P2B-rlc3
Rrlc115 P2B nrlc115_1 2035.1614235
Lrlc115 nrlc115_1 nrlc115_2 0.000156953596265
Crlc115 nrlc115_2 rlc3 4.21047446329e-14
* RLC[120] P2B-rlc8
Rrlc120 P2B nrlc120_1 1.52241788981e+13
Lrlc120 nrlc120_1 nrlc120_2 0.94176103625
Crlc120 nrlc120_2 rlc8 0.001
* RLC[125] P2B-rlc13
Rrlc125 P2B nrlc125_1 203994.853047
Lrlc125 nrlc125_1 nrlc125_2 1
Crlc125 nrlc125_2 rlc13 2.670048011e-14
* RLC[133] P3B-rlc3
Rrlc133 P3B nrlc133_1 1.30515266566e+13
Lrlc133 nrlc133_1 nrlc133_2 6.42812862699e-07
Crlc133 nrlc133_2 rlc3 1.33094488284e-07
* RLC[140] P3B-rlc10
Rrlc140 P3B nrlc140_1 39.9864946562
Lrlc140 nrlc140_1 nrlc140_2 4.77976333112e-14
Crlc140 nrlc140_2 rlc10 5.50113715081e-12
* RLC[144] P3B-rlc14
Rrlc144 P3B nrlc144_1 1488094.43972
Lrlc144 nrlc144_1 nrlc144_2 0.235449641652
Crlc144 nrlc144_2 rlc14 1.18139338961e-16
* RLC[146] P3B-GND
Rrlc146 P3B nrlc146_1 318908.525347
Lrlc146 nrlc146_1 nrlc146_2 1
Crlc146 nrlc146_2 GND 1.09250952458e-14
* RLC[154] P4B-rlc7
Rrlc154 P4B nrlc154_1 59464.7699251
Lrlc154 nrlc154_1 nrlc154_2 2.25329269411e-09
Crlc154 nrlc154_2 rlc7 1.23424481902e-14
* RLC[163] P4B-GND
Rrlc163 P4B nrlc163_1 4.25584885495e+12
Lrlc163 nrlc163_1 nrlc163_2 7.35424669012e-06
Crlc163 nrlc163_2 GND 2.04247169253e-06
* RLC[171] rlc0-rlc8
Rrlc171 rlc0 nrlc171_1 32.102476619
Lrlc171 nrlc171_1 nrlc171_2 1.34095454355e-10
Crlc171 nrlc171_2 rlc8 6.23796729983e-08
* RLC[177] rlc0-rlc14
Rrlc177 rlc0 nrlc177_1 32.1024766448
Lrlc177 nrlc177_1 nrlc177_2 7.76207956602e-09
Crlc177 nrlc177_2 rlc14 1.49994803667e-07
* RLC[185] rlc1-rlc7
Rrlc185 rlc1 nrlc185_1 1.15092359085
Lrlc185 nrlc185_1 nrlc185_2 2.00868430859e-09
Crlc185 nrlc185_2 rlc7 1.85664319455e-10
* RLC[220] rlc3-rlc15
Rrlc220 rlc3 nrlc220_1 1.00198803183
Lrlc220 nrlc220_1 nrlc220_2 0.901475314937
Crlc220 nrlc220_2 rlc15 0.000997668502293
* RLC[221] rlc3-GND
Rrlc221 rlc3 nrlc221_1 0.01
Lrlc221 nrlc221_1 nrlc221_2 1.31085905375e-09
Crlc221 nrlc221_2 GND 4.36099819894e-08
* RLC[224] rlc4-rlc7
Rrlc224 rlc4 nrlc224_1 0.0768634450733
Lrlc224 nrlc224_1 nrlc224_2 5.80598861737e-12
Crlc224 nrlc224_2 rlc7 9.45892054563e-11
* RLC[230] rlc4-rlc13
Rrlc230 rlc4 nrlc230_1 2.07176089883
Lrlc230 nrlc230_1 nrlc230_2 1.04765112381e-09
Crlc230 nrlc230_2 rlc13 8.2576557643e-10
* RLC[243] rlc5-rlc15
Rrlc243 rlc5 nrlc243_1 1.25351575945
Lrlc243 nrlc243_1 nrlc243_2 0.0182335291019
Crlc243 nrlc243_2 rlc15 1.28934347979e-05
* RLC[264] rlc8-rlc9
Rrlc264 rlc8 nrlc264_1 32.1146243678
Lrlc264 nrlc264_1 nrlc264_2 7.42932385473e-10
Crlc264 nrlc264_2 rlc9 5.42922753906e-05
* RLC[274] rlc9-rlc12
Rrlc274 rlc9 nrlc274_1 6.9632004194
Lrlc274 nrlc274_1 nrlc274_2 1.06350890983e-10
Crlc274 nrlc274_2 rlc12 2.3327976911e-12
* RLC[278] rlc9-GND
Rrlc278 rlc9 nrlc278_1 33.5191279109
Lrlc278 nrlc278_1 nrlc278_2 9.11597648737e-11
Crlc278 nrlc278_2 GND 3.14470260114e-08
* RLC[282] rlc10-rlc14
Rrlc282 rlc10 nrlc282_1 32.0971893035
Lrlc282 nrlc282_1 nrlc282_2 5.12366051946e-08
Crlc282 nrlc282_2 rlc14 1.65685051395e-06
* RLC[296] rlc13-GND
Rrlc296 rlc13 nrlc296_1 9843.2498264
Lrlc296 nrlc296_1 nrlc296_2 2.0752677023e-08
Crlc296 nrlc296_2 GND 6.1239460036e-15
* DC[0] P1A-P2A
Rdc0 P1A ndc0_1 0.0859263899665
Ldc0 ndc0_1 P2A 1.05995416417e-07
* DC[4] P1A-P2B
Rdc4 P1A ndc4_1 2420793856.86
Ldc4 ndc4_1 P2B 1
* DC[6] P1A-P4B
Rdc6 P1A ndc6_1 104703806.881
Ldc6 ndc6_1 P4B 1
* DC[23] P3A-P4A
Rdc23 P3A ndc23_1 0.130050896933
Ldc23 ndc23_1 P4A 1.57034819648e-07
* DC[28] P3A-dc0
Rdc28 P3A ndc28_1 25.3991474247
Ldc28 ndc28_1 dc0 4.86265222173e-06
* DC[33] P4A-P1B
Rdc33 P4A ndc33_1 205.628936831
Ldc33 ndc33_1 P1B 3.59364407202e-05
* DC[35] P4A-P3B
Rdc35 P4A ndc35_1 185.373503516
Ldc35 ndc35_1 P3B 2.95031094029e-05
* DC[42] P1B-P2B
Rdc42 P1B ndc42_1 0.011081811148
Ldc42 ndc42_1 P2B 7.09599398556e-07
* DC[43] P1B-P3B
Rdc43 P1B ndc43_1 0.01
Ldc43 ndc43_1 P3B 8.50200060285e-09
* DC[46] P1B-dc1
Rdc46 P1B ndc46_1 0.01
Ldc46 ndc46_1 dc1 2.20198650706e-08
* DC[47] P1B-dc2
Rdc47 P1B ndc47_1 0.01
Ldc47 ndc47_1 dc2 1.00542186813e-07
* DC[48] P1B-dc3
Rdc48 P1B ndc48_1 0.01
Ldc48 ndc48_1 dc3 2.20195957313e-08
* DC[50] P2B-P3B
Rdc50 P2B ndc50_1 0.01
Ldc50 ndc50_1 P3B 2.75114292924e-07
* DC[51] P2B-P4B
Rdc51 P2B ndc51_1 0.01
Ldc51 ndc51_1 P4B 8.92641009038e-09
* DC[52] P2B-dc0
Rdc52 P2B ndc52_1 0.01
Ldc52 ndc52_1 dc0 8.01113020837e-09
* DC[53] P2B-dc1
Rdc53 P2B ndc53_1 0.01
Ldc53 ndc53_1 dc1 1.09030901824e-06
* DC[54] P2B-dc2
Rdc54 P2B ndc54_1 0.0708823560858
Ldc54 ndc54_1 dc2 1.12812773491e-08
* DC[55] P2B-dc3
Rdc55 P2B ndc55_1 0.01
Ldc55 ndc55_1 dc3 1.09030919198e-06
* DC[57] P3B-P4B
Rdc57 P3B ndc57_1 0.01
Ldc57 ndc57_1 P4B 3.74021559717e-08
* DC[59] P3B-dc1
Rdc59 P3B ndc59_1 0.01
Ldc59 ndc59_1 dc1 1.59154943092e-09
* DC[60] P3B-dc2
Rdc60 P3B ndc60_1 0.01
Ldc60 ndc60_1 dc2 6.55584862145e-07
* DC[61] P3B-dc3
Rdc61 P3B ndc61_1 0.01
Ldc61 ndc61_1 dc3 1.59154943092e-09
* DC[63] P4B-dc0
Rdc63 P4B ndc63_1 0.015784689647
Ldc63 ndc63_1 dc0 2.5122113825e-09
* DC[64] P4B-dc1
Rdc64 P4B ndc64_1 0.01
Ldc64 ndc64_1 dc1 2.8225459424e-07
* DC[65] P4B-dc2
Rdc65 P4B ndc65_1 0.01
Ldc65 ndc65_1 dc2 2.16950444996e-07
* DC[66] P4B-dc3
Rdc66 P4B ndc66_1 0.01
Ldc66 ndc66_1 dc3 2.8225850074e-07
* DC[77] dc3-GND
Rdc77 dc3 ndc77_1 2.19840472252e+13
Ldc77 ndc77_1 GND 1
* ---- leaks
Rleak_P1A P1A GND 1e+12
Rleak_P1B P1B GND 1e+12
Rleak_P2A P2A GND 1e+12
Rleak_P2B P2B GND 1e+12
Rleak_P3A P3A GND 1e+12
Rleak_P3B P3B GND 1e+12
Rleak_P4A P4A GND 1e+12
Rleak_P4B P4B GND 1e+12
Rleak_dc0 dc0 GND 1e+12
Rleak_dc1 dc1 GND 1e+12
Rleak_dc2 dc2 GND 1e+12
Rleak_dc3 dc3 GND 1e+12
Rleak_rlc0 rlc0 GND 1e+12
Rleak_rlc1 rlc1 GND 1e+12
Rleak_rlc10 rlc10 GND 1e+12
Rleak_rlc12 rlc12 GND 1e+12
Rleak_rlc13 rlc13 GND 1e+12
Rleak_rlc14 rlc14 GND 1e+12
Rleak_rlc15 rlc15 GND 1e+12
Rleak_rlc3 rlc3 GND 1e+12
Rleak_rlc4 rlc4 GND 1e+12
Rleak_rlc5 rlc5 GND 1e+12
Rleak_rlc7 rlc7 GND 1e+12
Rleak_rlc8 rlc8 GND 1e+12
Rleak_rlc9 rlc9 GND 1e+12
.ends fitted
