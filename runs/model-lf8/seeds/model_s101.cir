* fitted: 8-port fitted model, reference z0 = 50 Ohm
* every pin is a port against GND
.subckt fitted P1A P1B P2A P2B P3A P3B P4A P4B GND
* ---- branches
* RLC[0] P1A-P2A
Rrlc0 P1A nrlc0_1 15.675365982
Lrlc0 nrlc0_1 nrlc0_2 0.917825781208
Crlc0 nrlc0_2 P2A 0.001
* RLC[1] P1A-P3A
Rrlc1 P1A nrlc1_1 72024.0868029
Lrlc1 nrlc1_1 nrlc1_2 3.4200819745e-11
Crlc1 nrlc1_2 P3A 7.93142998313e-07
* RLC[2] P1A-P4A
Rrlc2 P1A nrlc2_1 74953.4017995
Lrlc2 nrlc2_1 nrlc2_2 0.000143108862495
Crlc2 nrlc2_2 P4A 0.001
* RLC[3] P1A-P1B
Rrlc3 P1A nrlc3_1 155.996064134
Lrlc3 nrlc3_1 nrlc3_2 2.35553092746e-06
Crlc3 nrlc3_2 P1B 1.59626203109e-11
* RLC[4] P1A-P2B
Rrlc4 P1A nrlc4_1 290.697386313
Lrlc4 nrlc4_1 nrlc4_2 2.56367624965e-11
Crlc4 nrlc4_2 P2B 1.91474249641e-11
* RLC[5] P1A-P3B
Rrlc5 P1A nrlc5_1 291.218824633
Lrlc5 nrlc5_1 nrlc5_2 5.11313551755e-06
Crlc5 nrlc5_2 P3B 1.52059044988e-11
* RLC[6] P1A-P4B
Rrlc6 P1A nrlc6_1 3.43641403928
Lrlc6 nrlc6_1 nrlc6_2 1.80509265386e-07
Crlc6 nrlc6_2 P4B 1.69842361645e-11
* RLC[7] P1A-rlc0
Rrlc7 P1A nrlc7_1 0.01
Lrlc7 nrlc7_1 nrlc7_2 9.27241204796e-15
Crlc7 nrlc7_2 rlc0 9.847964552e-13
* RLC[10] P1A-rlc3
Rrlc10 P1A nrlc10_1 190927.952408
Lrlc10 nrlc10_1 nrlc10_2 1
Crlc10 nrlc10_2 rlc3 3.04802454893e-14
* RLC[15] P1A-rlc8
Rrlc15 P1A nrlc15_1 117316.37842
Lrlc15 nrlc15_1 nrlc15_2 1
Crlc15 nrlc15_2 rlc8 8.07309745329e-14
* RLC[22] P1A-rlc15
Rrlc22 P1A nrlc22_1 78139.1887789
Lrlc22 nrlc22_1 nrlc22_2 1
Crlc22 nrlc22_2 rlc15 1.81978337952e-13
* RLC[24] P2A-P3A
Rrlc24 P2A nrlc24_1 74926.795463
Lrlc24 nrlc24_1 nrlc24_2 0.000142049175117
Crlc24 nrlc24_2 P3A 0.001
* RLC[25] P2A-P4A
Rrlc25 P2A nrlc25_1 778.591253532
Lrlc25 nrlc25_1 nrlc25_2 1.21084544762e-12
Crlc25 nrlc25_2 P4A 1.55540117347e-11
* RLC[26] P2A-P1B
Rrlc26 P2A nrlc26_1 85306.8443542
Lrlc26 nrlc26_1 nrlc26_2 3.44248240621e-09
Crlc26 nrlc26_2 P1B 0.001
* RLC[27] P2A-P2B
Rrlc27 P2A nrlc27_1 155.2430321
Lrlc27 nrlc27_1 nrlc27_2 2.20740363157e-06
Crlc27 nrlc27_2 P2B 1.58591688093e-11
* RLC[28] P2A-P3B
Rrlc28 P2A nrlc28_1 3.65756879609
Lrlc28 nrlc28_1 nrlc28_2 2.10411770936e-07
Crlc28 nrlc28_2 P3B 1.74760192712e-11
* RLC[29] P2A-P4B
Rrlc29 P2A nrlc29_1 476.628602899
Lrlc29 nrlc29_1 nrlc29_2 6.15066604383e-06
Crlc29 nrlc29_2 P4B 1.72717424242e-11
* RLC[41] P2A-rlc11
Rrlc41 P2A nrlc41_1 861.430213389
Lrlc41 nrlc41_1 nrlc41_2 5.87340066262e-05
Crlc41 nrlc41_2 rlc11 8.79441424836e-14
* RLC[48] P3A-P1B
Rrlc48 P3A nrlc48_1 887.040372408
Lrlc48 nrlc48_1 nrlc48_2 8.68025419175e-06
Crlc48 nrlc48_2 P1B 1.53688734254e-11
* RLC[49] P3A-P2B
Rrlc49 P3A nrlc49_1 106.4144016
Lrlc49 nrlc49_1 nrlc49_2 1.09436230713e-14
Crlc49 nrlc49_2 P2B 1.52501851826e-11
* RLC[50] P3A-P3B
Rrlc50 P3A nrlc50_1 188.184557694
Lrlc50 nrlc50_1 nrlc50_2 1.9500090661e-06
Crlc50 nrlc50_2 P3B 1.04210384446e-11
* RLC[51] P3A-P4B
Rrlc51 P3A nrlc51_1 4.41100058525
Lrlc51 nrlc51_1 nrlc51_2 2.87268590551e-07
Crlc51 nrlc51_2 P4B 1.6404817501e-11
* RLC[52] P3A-rlc0
Rrlc52 P3A nrlc52_1 15889.3752325
Lrlc52 nrlc52_1 nrlc52_2 5.02913584061e-05
Crlc52 nrlc52_2 rlc0 1.81580919222e-14
* RLC[58] P3A-rlc6
Rrlc58 P3A nrlc58_1 119001.695204
Lrlc58 nrlc58_1 nrlc58_2 1
Crlc58 nrlc58_2 rlc6 7.84605222319e-14
* RLC[62] P3A-rlc10
Rrlc62 P3A nrlc62_1 3344.45904318
Lrlc62 nrlc62_1 nrlc62_2 4.19213230231e-06
Crlc62 nrlc62_2 rlc10 2.09423662516e-13
* RLC[67] P3A-rlc15
Rrlc67 P3A nrlc67_1 1823.72449295
Lrlc67 nrlc67_1 nrlc67_2 3.20850044647e-14
Crlc67 nrlc67_2 rlc15 1.41237892692e-14
* RLC[69] P4A-P1B
Rrlc69 P4A nrlc69_1 55829.3493614
Lrlc69 nrlc69_1 nrlc69_2 2.11655766259e-11
Crlc69 nrlc69_2 P1B 0.001
* RLC[70] P4A-P2B
Rrlc70 P4A nrlc70_1 1041.72927584
Lrlc70 nrlc70_1 nrlc70_2 8.1809663126e-06
Crlc70 nrlc70_2 P2B 1.68139219793e-11
* RLC[71] P4A-P3B
Rrlc71 P4A nrlc71_1 54696.3105091
Lrlc71 nrlc71_1 nrlc71_2 9.13563492166e-11
Crlc71 nrlc71_2 P3B 0.001
* RLC[72] P4A-P4B
Rrlc72 P4A nrlc72_1 271.512425648
Lrlc72 nrlc72_1 nrlc72_2 2.71471005347e-06
Crlc72 nrlc72_2 P4B 1.23649455754e-11
* RLC[80] P4A-rlc7
Rrlc80 P4A nrlc80_1 99829.7153317
Lrlc80 nrlc80_1 nrlc80_2 1
Crlc80 nrlc80_2 rlc7 1.11490490247e-13
* RLC[88] P4A-rlc15
Rrlc88 P4A nrlc88_1 11825.4847611
Lrlc88 nrlc88_1 nrlc88_2 0.00175079026942
Crlc88 nrlc88_2 rlc15 1.39108513315e-14
* RLC[99] P1B-rlc6
Rrlc99 P1B nrlc99_1 341.404016095
Lrlc99 nrlc99_1 nrlc99_2 1.80932626408e-15
Crlc99 nrlc99_2 rlc6 1.24362678352e-13
* RLC[100] P1B-rlc7
Rrlc100 P1B nrlc100_1 119090.983467
Lrlc100 nrlc100_1 nrlc100_2 1
Crlc100 nrlc100_2 rlc7 7.83429150491e-14
* RLC[109] P1B-GND
Rrlc109 P1B nrlc109_1 171802.055499
Lrlc109 nrlc109_1 nrlc109_2 1
Crlc109 nrlc109_2 GND 3.76444346662e-14
* RLC[111] P2B-P4B
Rrlc111 P2B nrlc111_1 0.01
Lrlc111 nrlc111_1 nrlc111_2 7.84473700766e-09
Crlc111 nrlc111_2 P4B 0.001
* RLC[116] P2B-rlc4
Rrlc116 P2B nrlc116_1 171669.105633
Lrlc116 nrlc116_1 nrlc116_2 1
Crlc116 nrlc116_2 rlc4 3.77027650285e-14
* RLC[117] P2B-rlc5
Rrlc117 P2B nrlc117_1 26074.7688697
Lrlc117 nrlc117_1 nrlc117_2 2.55959905178e-05
Crlc117 nrlc117_2 rlc5 1.85102485175e-14
* RLC[132] P3B-rlc2
Rrlc132 P3B nrlc132_1 158433.118173
Lrlc132 nrlc132_1 nrlc132_2 1
Crlc132 nrlc132_2 rlc2 4.42655180255e-14
* RLC[135] P3B-rlc5
Rrlc135 P3B nrlc135_1 119633.206312
Lrlc135 nrlc135_1 nrlc135_2 1
Crlc135 nrlc135_2 rlc5 7.76343650825e-14
* RLC[139] P3B-rlc9
Rrlc139 P3B nrlc139_1 28.7514116293
Lrlc139 nrlc139_1 nrlc139_2 1.38704360217e-06
Crlc139 nrlc139_2 rlc9 1.86435777909e-12
* RLC[140] P3B-rlc10
Rrlc140 P3B nrlc140_1 70852.5039803
Lrlc140 nrlc140_1 nrlc140_2 1
Crlc140 nrlc140_2 rlc10 2.21333465647e-13
* RLC[153] P4B-rlc6
Rrlc153 P4B nrlc153_1 135742.28956
Lrlc153 nrlc153_1 nrlc153_2 1
Crlc153 nrlc153_2 rlc6 6.0301365999e-14
* RLC[160] P4B-rlc13
Rrlc160 P4B nrlc160_1 0.11744191172
Lrlc160 nrlc160_1 nrlc160_2 1.65148804946e-11
Crlc160 nrlc160_2 rlc13 1.33041367974e-12
* RLC[165] rlc0-rlc2
Rrlc165 rlc0 nrlc165_1 51.0872268386
Lrlc165 nrlc165_1 nrlc165_2 1
Crlc165 nrlc165_2 rlc2 4.25728606681e-07
* RLC[167] rlc0-rlc4
Rrlc167 rlc0 nrlc167_1 76.0057786344
Lrlc167 nrlc167_1 nrlc167_2 0.741935849106
Crlc167 nrlc167_2 rlc4 1.42702184574e-07
* RLC[169] rlc0-rlc6
Rrlc169 rlc0 nrlc169_1 0.01
Lrlc169 nrlc169_1 nrlc169_2 2.80921883043e-15
Crlc169 nrlc169_2 rlc6 5.93630991091e-13
* RLC[174] rlc0-rlc11
Rrlc174 rlc0 nrlc174_1 48.1095280107
Lrlc174 nrlc174_1 nrlc174_2 1
Crlc174 nrlc174_2 rlc11 4.80059753951e-07
* RLC[176] rlc0-rlc13
Rrlc176 rlc0 nrlc176_1 3985.15946611
Lrlc176 nrlc176_1 nrlc176_2 0.361833076614
Crlc176 nrlc176_2 rlc13 9.77721044305e-09
* RLC[179] rlc0-GND
Rrlc179 rlc0 nrlc179_1 0.300046861969
Lrlc179 nrlc179_1 nrlc179_2 2.18412849982e-06
Crlc179 nrlc179_2 GND 2.69561272747e-08
* RLC[180] rlc1-rlc2
Rrlc180 rlc1 nrlc180_1 8.45989252814
Lrlc180 nrlc180_1 nrlc180_2 1
Crlc180 nrlc180_2 rlc2 1.55248637967e-05
* RLC[182] rlc1-rlc4
Rrlc182 rlc1 nrlc182_1 164.444475195
Lrlc182 nrlc182_1 nrlc182_2 0.120442748797
Crlc182 nrlc182_2 rlc4 4.94879626448e-09
* RLC[184] rlc1-rlc6
Rrlc184 rlc1 nrlc184_1 1.67323638536
Lrlc184 nrlc184_1 nrlc184_2 0.71388938368
Crlc184 nrlc184_2 rlc6 0.000283317769613
* RLC[185] rlc1-rlc7
Rrlc185 rlc1 nrlc185_1 0.937999864342
Lrlc185 nrlc185_1 nrlc185_2 0.391868812599
Crlc185 nrlc185_2 rlc7 0.000494871724667
* RLC[186] rlc1-rlc8
Rrlc186 rlc1 nrlc186_1 7.22584956443
Lrlc186 nrlc186_1 nrlc186_2 0.0770582157727
Crlc186 nrlc186_2 rlc8 1.63982917222e-06
* RLC[187] rlc1-rlc9
Rrlc187 rlc1 nrlc187_1 1.43698235475
Lrlc187 nrlc187_1 nrlc187_2 1
Crlc187 nrlc187_2 rlc9 0.000538089626905
* RLC[188] rlc1-rlc10
Rrlc188 rlc1 nrlc188_1 451.492236495
Lrlc188 nrlc188_1 nrlc188_2 0.750025432219
Crlc188 nrlc188_2 rlc10 4.08820727395e-09
* RLC[189] rlc1-rlc11
Rrlc189 rlc1 nrlc189_1 1.06605848081
Lrlc189 nrlc189_1 nrlc189_2 0.790936782248
Crlc189 nrlc189_2 rlc11 0.000863818140269
* RLC[190] rlc1-rlc12
Rrlc190 rlc1 nrlc190_1 8.90725697406
Lrlc190 nrlc190_1 nrlc190_2 0.759064516092
Crlc190 nrlc190_2 rlc12 1.06303659851e-05
* RLC[193] rlc1-rlc15
Rrlc193 rlc1 nrlc193_1 4.95705161056
Lrlc193 nrlc193_1 nrlc193_2 0.286385489024
Crlc193 nrlc193_2 rlc15 1.29497569726e-05
* RLC[194] rlc1-GND
Rrlc194 rlc1 nrlc194_1 5.41673108004
Lrlc194 nrlc194_1 nrlc194_2 1
Crlc194 nrlc194_2 GND 3.78689218281e-05
* RLC[195] rlc2-rlc3
Rrlc195 rlc2 nrlc195_1 1.35998131903
Lrlc195 nrlc195_1 nrlc195_2 1
Crlc195 nrlc195_2 rlc3 0.000600746991893
* RLC[196] rlc2-rlc4
Rrlc196 rlc2 nrlc196_1 17.8146288148
Lrlc196 nrlc196_1 nrlc196_2 1
Crlc196 nrlc196_2 rlc4 3.50109531976e-06
* RLC[198] rlc2-rlc6
Rrlc198 rlc2 nrlc198_1 1.07491209168
Lrlc198 nrlc198_1 nrlc198_2 1
Crlc198 nrlc198_2 rlc6 0.000961637950051
* RLC[199] rlc2-rlc7
Rrlc199 rlc2 nrlc199_1 11.5797432894
Lrlc199 nrlc199_1 nrlc199_2 1
Crlc199 nrlc199_2 rlc7 8.28628043684e-06
* RLC[200] rlc2-rlc8
Rrlc200 rlc2 nrlc200_1 5.30368443802
Lrlc200 nrlc200_1 nrlc200_2 1
Crlc200 nrlc200_2 rlc8 3.95004586251e-05
* RLC[201] rlc2-rlc9
Rrlc201 rlc2 nrlc201_1 92.5791581013
Lrlc201 nrlc201_1 nrlc201_2 1
Crlc201 nrlc201_2 rlc9 1.29637616164e-07
* RLC[205] rlc2-rlc13
Rrlc205 rlc2 nrlc205_1 11.9350486059
Lrlc205 nrlc205_1 nrlc205_2 1
Crlc205 nrlc205_2 rlc13 7.8002604953e-06
* RLC[206] rlc2-rlc14
Rrlc206 rlc2 nrlc206_1 246.292216899
Lrlc206 nrlc206_1 nrlc206_2 1
Crlc206 nrlc206_2 rlc14 1.83170746266e-08
* RLC[207] rlc2-rlc15
Rrlc207 rlc2 nrlc207_1 1.09021336262
Lrlc207 nrlc207_1 nrlc207_2 1
Crlc207 nrlc207_2 rlc15 0.000934833977573
* RLC[208] rlc2-GND
Rrlc208 rlc2 nrlc208_1 8.03673236754
Lrlc208 nrlc208_1 nrlc208_2 1
Crlc208 nrlc208_2 GND 1.72027737848e-05
* RLC[210] rlc3-rlc5
Rrlc210 rlc3 nrlc210_1 169.559347192
Lrlc210 nrlc210_1 nrlc210_2 1
Crlc210 nrlc210_2 rlc5 3.86468426427e-08
* RLC[214] rlc3-rlc9
Rrlc214 rlc3 nrlc214_1 1.44378562076
Lrlc214 nrlc214_1 nrlc214_2 0.342095881813
Crlc214 nrlc214_2 rlc9 0.000458790760131
* RLC[215] rlc3-rlc10
Rrlc215 rlc3 nrlc215_1 0.335191375171
Lrlc215 nrlc215_1 nrlc215_2 6.67892143294e-09
Crlc215 nrlc215_2 rlc10 6.6050811051e-11
* RLC[216] rlc3-rlc11
Rrlc216 rlc3 nrlc216_1 370.17109675
Lrlc216 nrlc216_1 nrlc216_2 0.435040992024
Crlc216 nrlc216_2 rlc11 3.52762701443e-09
* RLC[217] rlc3-rlc12
Rrlc217 rlc3 nrlc217_1 6.67475363545
Lrlc217 nrlc217_1 nrlc217_2 0.0816869256678
Crlc217 nrlc217_2 rlc12 2.03722764505e-06
* RLC[218] rlc3-rlc13
Rrlc218 rlc3 nrlc218_1 0.01
Lrlc218 nrlc218_1 nrlc218_2 9.84961982266e-07
Crlc218 nrlc218_2 rlc13 2.29721148799e-05
* RLC[219] rlc3-rlc14
Rrlc219 rlc3 nrlc219_1 1.18404854848
Lrlc219 nrlc219_1 nrlc219_2 6.84515788132e-09
Crlc219 nrlc219_2 rlc14 5.42502745653e-12
* RLC[220] rlc3-rlc15
Rrlc220 rlc3 nrlc220_1 1.27934647057
Lrlc220 nrlc220_1 nrlc220_2 1
Crlc220 nrlc220_2 rlc15 0.000678861438201
* RLC[221] rlc3-GND
Rrlc221 rlc3 nrlc221_1 4.52927136824
Lrlc221 nrlc221_1 nrlc221_2 8.23348469837e-06
Crlc221 nrlc221_2 GND 4.45948276118e-10
* RLC[222] rlc4-rlc5
Rrlc222 rlc4 nrlc222_1 0.149237379122
Lrlc222 nrlc222_1 nrlc222_2 0.000799591127798
Crlc222 nrlc222_2 rlc5 3.98905689188e-05
* RLC[223] rlc4-rlc6
Rrlc223 rlc4 nrlc223_1 0.208183884224
Lrlc223 nrlc223_1 nrlc223_2 0.0288264120009
Crlc223 nrlc223_2 rlc6 0.000739016041706
* RLC[225] rlc4-rlc8
Rrlc225 rlc4 nrlc225_1 2.48458811971
Lrlc225 nrlc225_1 nrlc225_2 0.00346574670725
Crlc225 nrlc225_2 rlc8 6.23800188008e-07
* RLC[227] rlc4-rlc10
Rrlc227 rlc4 nrlc227_1 2.08899399948
Lrlc227 nrlc227_1 nrlc227_2 1
Crlc227 nrlc227_2 rlc10 0.000254614484161
* RLC[228] rlc4-rlc11
Rrlc228 rlc4 nrlc228_1 104269.363385
Lrlc228 nrlc228_1 nrlc228_2 0.0614782673029
Crlc228 nrlc228_2 rlc11 6.28297982978e-15
* RLC[231] rlc4-rlc14
Rrlc231 rlc4 nrlc231_1 2.52696344422
Lrlc231 nrlc231_1 nrlc231_2 1.17342255297e-10
Crlc231 nrlc231_2 rlc14 2.04180377725e-14
* RLC[232] rlc4-rlc15
Rrlc232 rlc4 nrlc232_1 4.69957781404
Lrlc232 nrlc232_1 nrlc232_2 0.000251474547972
Crlc232 nrlc232_2 rlc15 1.2651261625e-08
* RLC[233] rlc4-GND
Rrlc233 rlc4 nrlc233_1 1.0940044573
Lrlc233 nrlc233_1 nrlc233_2 1
Crlc233 nrlc233_2 GND 0.000928366173088
* RLC[234] rlc5-rlc6
Rrlc234 rlc5 nrlc234_1 21.5843857971
Lrlc234 nrlc234_1 nrlc234_2 0.0940803882173
Crlc234 nrlc234_2 rlc6 2.24376413333e-07
* RLC[235] rlc5-rlc7
Rrlc235 rlc5 nrlc235_1 2.35561656883
Lrlc235 nrlc235_1 nrlc235_2 1.01940430076e-07
Crlc235 nrlc235_2 rlc7 2.04124320151e-11
* RLC[238] rlc5-rlc10
Rrlc238 rlc5 nrlc238_1 1.41393696862
Lrlc238 nrlc238_1 nrlc238_2 1
Crlc238 nrlc238_2 rlc10 0.000555772931899
* RLC[239] rlc5-rlc11
Rrlc239 rlc5 nrlc239_1 0.623743798445
Lrlc239 nrlc239_1 nrlc239_2 0.248517140929
Crlc239 nrlc239_2 rlc11 0.000877784475062
* RLC[243] rlc5-rlc15
Rrlc243 rlc5 nrlc243_1 4.83947574804
Lrlc243 nrlc243_1 nrlc243_2 0.62147632293
Crlc243 nrlc243_2 rlc15 2.94839348175e-05
* RLC[244] rlc5-GND
Rrlc244 rlc5 nrlc244_1 1.07963460631
Lrlc244 nrlc244_1 nrlc244_2 1
Crlc244 nrlc244_2 GND 0.000953243597134
* RLC[246] rlc6-rlc8
Rrlc246 rlc6 nrlc246_1 57.7104474659
Lrlc246 nrlc246_1 nrlc246_2 0.964047020554
Crlc246 nrlc246_2 rlc8 3.21622796614e-07
* RLC[247] rlc6-rlc9
Rrlc247 rlc6 nrlc247_1 1.5830655711
Lrlc247 nrlc247_1 nrlc247_2 1
Crlc247 nrlc247_2 rlc9 0.000443363240684
* RLC[248] rlc6-rlc10
Rrlc248 rlc6 nrlc248_1 9.91481483156
Lrlc248 nrlc248_1 nrlc248_2 1
Crlc248 nrlc248_2 rlc10 1.13028580918e-05
* RLC[249] rlc6-rlc11
Rrlc249 rlc6 nrlc249_1 3.06421381849
Lrlc249 nrlc249_1 nrlc249_2 0.0671184290749
Crlc249 nrlc249_2 rlc11 7.94257163027e-06
* RLC[252] rlc6-rlc14
Rrlc252 rlc6 nrlc252_1 11.2327998552
Lrlc252 nrlc252_1 nrlc252_2 0.0748944641876
Crlc252 nrlc252_2 rlc14 6.59524855076e-07
* RLC[253] rlc6-rlc15
Rrlc253 rlc6 nrlc253_1 3.28414719262
Lrlc253 nrlc253_1 nrlc253_2 2.49655645039e-05
Crlc253 nrlc253_2 rlc15 2.57189748557e-09
* RLC[254] rlc6-GND
Rrlc254 rlc6 nrlc254_1 50.4827328165
Lrlc254 nrlc254_1 nrlc254_2 1
Crlc254 nrlc254_2 GND 4.35985230097e-07
* RLC[256] rlc7-rlc9
Rrlc256 rlc7 nrlc256_1 0.01
Lrlc256 nrlc256_1 nrlc256_2 1.01606408761e-11
Crlc256 nrlc256_2 rlc9 1.44185705274e-10
* RLC[257] rlc7-rlc10
Rrlc257 rlc7 nrlc257_1 0.0412318864563
Lrlc257 nrlc257_1 nrlc257_2 0.000547397762756
Crlc257 nrlc257_2 rlc10 0.000357761908087
* RLC[259] rlc7-rlc12
Rrlc259 rlc7 nrlc259_1 1.67900701659
Lrlc259 nrlc259_1 nrlc259_2 1
Crlc259 nrlc259_2 rlc12 0.000394141775321
* RLC[260] rlc7-rlc13
Rrlc260 rlc7 nrlc260_1 1291.12564129
Lrlc260 nrlc260_1 nrlc260_2 8.86534023701e-09
Crlc260 nrlc260_2 rlc13 1.66096052808e-12
* RLC[263] rlc7-GND
Rrlc263 rlc7 nrlc263_1 1.96456009275
Lrlc263 nrlc263_1 nrlc263_2 0.821770858582
Crlc263 nrlc263_2 GND 0.000913735549022
* RLC[264] rlc8-rlc9
Rrlc264 rlc8 nrlc264_1 479.778205548
Lrlc264 nrlc264_1 nrlc264_2 1
Crlc264 nrlc264_2 rlc9 4.82699066587e-09
* RLC[265] rlc8-rlc10
Rrlc265 rlc8 nrlc265_1 2.31957713888
Lrlc265 nrlc265_1 nrlc265_2 1
Crlc265 nrlc265_2 rlc10 0.000206509412392
* RLC[267] rlc8-rlc12
Rrlc267 rlc8 nrlc267_1 56.4360228004
Lrlc267 nrlc267_1 nrlc267_2 0.727204821936
Crlc267 nrlc267_2 rlc12 2.53688885188e-07
* RLC[269] rlc8-rlc14
Rrlc269 rlc8 nrlc269_1 0.581936447898
Lrlc269 nrlc269_1 nrlc269_2 7.90673301599e-09
Crlc269 nrlc269_2 rlc14 2.59419995398e-11
* RLC[271] rlc8-GND
Rrlc271 rlc8 nrlc271_1 1.65113822996
Lrlc271 nrlc271_1 nrlc271_2 1
Crlc271 nrlc271_2 GND 0.000407559128102
* RLC[272] rlc9-rlc10
Rrlc272 rlc9 nrlc272_1 0.0378714371989
Lrlc272 nrlc272_1 nrlc272_2 5.17453974621e-08
Crlc272 nrlc272_2 rlc10 4.00871927618e-08
* RLC[273] rlc9-rlc11
Rrlc273 rlc9 nrlc273_1 1.11213765317
Lrlc273 nrlc273_1 nrlc273_2 1
Crlc273 nrlc273_2 rlc11 0.000898339303671
* RLC[275] rlc9-rlc13
Rrlc275 rlc9 nrlc275_1 395.135256285
Lrlc275 nrlc275_1 nrlc275_2 0.0116341228785
Crlc275 nrlc275_2 rlc13 8.27941350826e-11
* RLC[283] rlc10-rlc15
Rrlc283 rlc10 nrlc283_1 0.01
Lrlc283 nrlc283_1 nrlc283_2 1.83896849269e-14
Crlc283 nrlc283_2 rlc15 7.37439129807e-13
* RLC[284] rlc10-GND
Rrlc284 rlc10 nrlc284_1 0.01
Lrlc284 nrlc284_1 nrlc284_2 2.4711232667e-14
Crlc284 nrlc284_2 GND 2.25946728551e-08
* RLC[285] rlc11-rlc12
Rrlc285 rlc11 nrlc285_1 0.0212342274417
Lrlc285 nrlc285_1 nrlc285_2 3.81570166285e-05
Crlc285 nrlc285_2 rlc12 9.40283839958e-05
* RLC[286] rlc11-rlc13
Rrlc286 rlc11 nrlc286_1 2.96988035051
Lrlc286 nrlc286_1 nrlc286_2 0.789326162212
Crlc286 nrlc286_2 rlc13 9.94342683201e-05
* RLC[287] rlc11-rlc14
Rrlc287 rlc11 nrlc287_1 6.99222386234
Lrlc287 nrlc287_1 nrlc287_2 0.277382566529
Crlc287 nrlc287_2 rlc14 6.3038519429e-06
* RLC[289] rlc11-GND
Rrlc289 rlc11 nrlc289_1 0.0720289880586
Lrlc289 nrlc289_1 nrlc289_2 5.32785006437e-12
Crlc289 nrlc289_2 GND 1.14102420737e-12
* RLC[290] rlc12-rlc13
Rrlc290 rlc12 nrlc290_1 4.37954050065
Lrlc290 nrlc290_1 nrlc290_2 0.0495197323036
Crlc290 nrlc290_2 rlc13 2.86865740585e-06
* RLC[291] rlc12-rlc14
Rrlc291 rlc12 nrlc291_1 0.343733447908
Lrlc291 nrlc291_1 nrlc291_2 0.0199209222122
Crlc291 nrlc291_2 rlc14 0.000187336905198
* RLC[292] rlc12-rlc15
Rrlc292 rlc12 nrlc292_1 0.01
Lrlc292 nrlc292_1 nrlc292_2 6.1582698349e-13
Crlc292 nrlc292_2 rlc15 1.21010446276e-09
* RLC[293] rlc12-GND
Rrlc293 rlc12 nrlc293_1 2.30409745325
Lrlc293 nrlc293_1 nrlc293_2 1
Crlc293 nrlc293_2 GND 0.000209293529899
* RLC[294] rlc13-rlc14
Rrlc294 rlc13 nrlc294_1 64.44327631
Lrlc294 nrlc294_1 nrlc294_2 0.157680345836
Crlc294 nrlc294_2 rlc14 4.21871153568e-08
* RLC[299] rlc15-GND
Rrlc299 rlc15 nrlc299_1 6011.6918149
Lrlc299 nrlc299_1 nrlc299_2 1
Crlc299 nrlc299_2 GND 3.07442620489e-11
* DC[0] P1A-P2A
Rdc0 P1A ndc0_1 0.370454123935
Ldc0 ndc0_1 P2A 4.33059224918e-07
* DC[3] P1A-P1B
Rdc3 P1A ndc3_1 651641.815358
Ldc3 ndc3_1 P1B 0.10371201604
* DC[7] P1A-dc0
Rdc7 P1A ndc7_1 97138.8729504
Ldc7 ndc7_1 dc0 0.0154601317964
* DC[9] P1A-dc2
Rdc9 P1A ndc9_1 55454.4309039
Ldc9 ndc9_1 dc2 0.0088258467947
* DC[13] P2A-P4A
Rdc13 P2A ndc13_1 108407.60468
Ldc13 ndc13_1 P4A 0.12519155696
* DC[15] P2A-P2B
Rdc15 P2A ndc15_1 130155.657961
Ldc15 ndc15_1 P2B 0.0207149163358
* DC[16] P2A-P3B
Rdc16 P2A ndc16_1 135905.00999
Ldc16 ndc16_1 P3B 0.0216299541308
* DC[17] P2A-P4B
Rdc17 P2A ndc17_1 129767.950038
Ldc17 ndc17_1 P4B 0.0206532107035
* DC[23] P3A-P4A
Rdc23 P3A ndc23_1 0.526225205437
Ldc23 ndc23_1 P4A 3.4758270165e-07
* DC[25] P3A-P2B
Rdc25 P3A ndc25_1 295997.91929
Ldc25 ndc25_1 P2B 0.047109532
* DC[27] P3A-P4B
Rdc27 P3A ndc27_1 413576.004055
Ldc27 ndc27_1 P4B 0.0658226653895
* DC[28] P3A-dc0
Rdc28 P3A ndc28_1 139132.99061
Ldc28 ndc28_1 dc0 0.0221437032028
* DC[30] P3A-dc2
Rdc30 P3A ndc30_1 27795.2980793
Ldc30 ndc30_1 dc2 0.00442375908404
* DC[34] P4A-P2B
Rdc34 P4A ndc34_1 81725.8946834
Ldc34 ndc34_1 P2B 0.0130070801175
* DC[36] P4A-P4B
Rdc36 P4A ndc36_1 79159.6367088
Ldc36 ndc36_1 P4B 0.0125986474756
* DC[42] P1B-P2B
Rdc42 P1B ndc42_1 0.0177342811847
Ldc42 ndc42_1 P2B 1.2173190867e-06
* DC[43] P1B-P3B
Rdc43 P1B ndc43_1 0.01
Ldc43 ndc43_1 P3B 8.42655196425e-09
* DC[44] P1B-P4B
Rdc44 P1B ndc44_1 0.01
Ldc44 ndc44_1 P4B 6.10601354386e-07
* DC[45] P1B-dc0
Rdc45 P1B ndc45_1 0.0616225533721
Ldc45 ndc45_1 dc0 9.80753397512e-09
* DC[46] P1B-dc1
Rdc46 P1B ndc46_1 0.01
Ldc46 ndc46_1 dc1 2.55948043479e-08
* DC[47] P1B-dc2
Rdc47 P1B ndc47_1 0.01
Ldc47 ndc47_1 dc2 2.36030978672e-08
* DC[48] P1B-dc3
Rdc48 P1B ndc48_1 0.01
Ldc48 ndc48_1 dc3 1.59154943092e-09
* DC[51] P2B-P4B
Rdc51 P2B ndc51_1 0.01
Ldc51 ndc51_1 P4B 6.05363182556e-09
* DC[52] P2B-dc0
Rdc52 P2B ndc52_1 0.01
Ldc52 ndc52_1 dc0 1.09698963581e-07
* DC[53] P2B-dc1
Rdc53 P2B ndc53_1 0.01
Ldc53 ndc53_1 dc1 9.39781226415e-07
* DC[54] P2B-dc2
Rdc54 P2B ndc54_1 0.01
Ldc54 ndc54_1 dc2 8.4947989961e-07
* DC[55] P2B-dc3
Rdc55 P2B ndc55_1 0.01
Ldc55 ndc55_1 dc3 6.7455407458e-07
* DC[57] P3B-P4B
Rdc57 P3B ndc57_1 0.01
Ldc57 ndc57_1 P4B 3.96029053061e-08
* DC[58] P3B-dc0
Rdc58 P3B ndc58_1 0.01
Ldc58 ndc58_1 dc0 1.31127633466e-07
* DC[59] P3B-dc1
Rdc59 P3B ndc59_1 0.01
Ldc59 ndc59_1 dc1 1.59154943092e-09
* DC[60] P3B-dc2
Rdc60 P3B ndc60_1 0.01
Ldc60 ndc60_1 dc2 1.59154943092e-09
* DC[61] P3B-dc3
Rdc61 P3B ndc61_1 0.01
Ldc61 ndc61_1 dc3 1.58493153244e-08
* DC[63] P4B-dc0
Rdc63 P4B ndc63_1 0.01
Ldc63 ndc63_1 dc0 1.27964469109e-06
* DC[64] P4B-dc1
Rdc64 P4B ndc64_1 0.01
Ldc64 ndc64_1 dc1 2.9904773333e-07
* DC[65] P4B-dc2
Rdc65 P4B ndc65_1 0.01
Ldc65 ndc65_1 dc2 1.89413279462e-07
* DC[70] dc0-dc3
Rdc70 dc0 ndc70_1 0.01
Ldc70 ndc70_1 dc3 2.77017192038e-06
* DC[74] dc1-GND
Rdc74 dc1 ndc74_1 185207318262
Ldc74 ndc74_1 GND 1
* ---- leaks
Rleak_P1A P1A GND 1e+12
Rleak_P1B P1B GND 1e+12
Rleak_P2A P2A GND 1e+12
Rleak_P2B P2B GND 1e+12
Rleak_P3A P3A GND 1e+12
Rleak_P3B P3B GND 1e+12
Rleak_P4A P4A GND 1e+12
Rleak_P4B P4B GND 1e+12
Rleak_dc0 dc0 GND 1e+12
Rleak_dc1 dc1 GND 1e+12
Rleak_dc2 dc2 GND 1e+12
Rleak_dc3 dc3 GND 1e+12
Rleak_rlc0 rlc0 GND 1e+12
Rleak_rlc1 rlc1 GND 1e+12
Rleak_rlc10 rlc10 GND 1e+12
Rleak_rlc11 rlc11 GND 1e+12
Rleak_rlc12 rlc12 GND 1e+12
Rleak_rlc13 rlc13 GND 1e+12
Rleak_rlc14 rlc14 GND 1e+12
Rleak_rlc15 rlc15 GND 1e+12
Rleak_rlc2 rlc2 GND 1e+12
Rleak_rlc3 rlc3 GND 1e+12
Rleak_rlc4 rlc4 GND 1e+12
Rleak_rlc5 rlc5 GND 1e+12
Rleak_rlc6 rlc6 GND 1e+12
Rleak_rlc7 rlc7 GND 1e+12
Rleak_rlc8 rlc8 GND 1e+12
Rleak_rlc9 rlc9 GND 1e+12
.ends fitted
