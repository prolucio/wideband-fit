* fitted: 8-port fitted model, reference z0 = 50 Ohm
* every pin is a port against GND
.subckt fitted P1A P1B P2A P2B P3A P3B P4A P4B GND
* ---- branches
* RLC[1] P1A-P3A
Rrlc1 P1A nrlc1_1 25867.2861536
Lrlc1 nrlc1_1 nrlc1_2 4.99643514397e-12
Crlc1 nrlc1_2 P3A 1.26008051677e-06
* RLC[2] P1A-P4A
Rrlc2 P1A nrlc2_1 29370.5866853
Lrlc2 nrlc2_1 nrlc2_2 7.17791426616e-05
Crlc2 nrlc2_2 P4A 0.001
* RLC[3] P1A-P1B
Rrlc3 P1A nrlc3_1 0.1424600219
Lrlc3 nrlc3_1 nrlc3_2 1.29692126271e-07
Crlc3 nrlc3_2 P1B 0.000257585911693
* RLC[4] P1A-P2B
Rrlc4 P1A nrlc4_1 0.201065637147
Lrlc4 nrlc4_1 nrlc4_2 8.34663102594e-08
Crlc4 nrlc4_2 P2B 0.000100905639989
* RLC[5] P1A-P3B
Rrlc5 P1A nrlc5_1 0.245422064505
Lrlc5 nrlc5_1 nrlc5_2 6.19537155116e-07
Crlc5 nrlc5_2 P3B 0.000205283041277
* RLC[6] P1A-P4B
Rrlc6 P1A nrlc6_1 5.97470200751
Lrlc6 nrlc6_1 nrlc6_2 1.33891293297e-15
Crlc6 nrlc6_2 P4B 0.000235089317596
* RLC[7] P1A-rlc0
Rrlc7 P1A nrlc7_1 191793.639001
Lrlc7 nrlc7_1 nrlc7_2 1
Crlc7 nrlc7_2 rlc0 3.02057130195e-14
* RLC[9] P1A-rlc2
Rrlc9 P1A nrlc9_1 359814108551
Lrlc9 nrlc9_1 nrlc9_2 0.153049253744
Crlc9 nrlc9_2 rlc2 0.001
* RLC[10] P1A-rlc3
Rrlc10 P1A nrlc10_1 151792.40494
Lrlc10 nrlc10_1 nrlc10_2 1
Crlc10 nrlc10_2 rlc3 4.82233533408e-14
* RLC[12] P1A-rlc5
Rrlc12 P1A nrlc12_1 30195.0789761
Lrlc12 nrlc12_1 nrlc12_2 0.00253211898894
Crlc12 nrlc12_2 rlc5 3.08581056043e-15
* RLC[21] P1A-rlc14
Rrlc21 P1A nrlc21_1 133026.81459
Lrlc21 nrlc21_1 nrlc21_2 1
Crlc21 nrlc21_2 rlc14 6.27883552862e-14
* RLC[24] P2A-P3A
Rrlc24 P2A nrlc24_1 29304.4056942
Lrlc24 nrlc24_1 nrlc24_2 7.14594799989e-05
Crlc24 nrlc24_2 P3A 0.001
* RLC[25] P2A-P4A
Rrlc25 P2A nrlc25_1 25886.8966806
Lrlc25 nrlc25_1 nrlc25_2 9.78471381369e-12
Crlc25 nrlc25_2 P4A 1.25996323877e-06
* RLC[26] P2A-P1B
Rrlc26 P2A nrlc26_1 2.13201354709
Lrlc26 nrlc26_1 nrlc26_2 5.9671138469e-16
Crlc26 nrlc26_2 P1B 0.000129170298379
* RLC[27] P2A-P2B
Rrlc27 P2A nrlc27_1 0.144056811476
Lrlc27 nrlc27_1 nrlc27_2 1.21715244484e-07
Crlc27 nrlc27_2 P2B 0.000251334990316
* RLC[28] P2A-P3B
Rrlc28 P2A nrlc28_1 4.78965980455
Lrlc28 nrlc28_1 nrlc28_2 2.27688202282e-09
Crlc28 nrlc28_2 P3B 0.000103331399306
* RLC[29] P2A-P4B
Rrlc29 P2A nrlc29_1 0.224236737695
Lrlc29 nrlc29_1 nrlc29_2 9.66403150055e-07
Crlc29 nrlc29_2 P4B 0.000211530857729
* RLC[32] P2A-rlc2
Rrlc32 P2A nrlc32_1 2.01210864806e+12
Lrlc32 nrlc32_1 nrlc32_2 0.118803363038
Crlc32 nrlc32_2 rlc2 2.23564936699e-07
* RLC[35] P2A-rlc5
Rrlc35 P2A nrlc35_1 112988.605876
Lrlc35 nrlc35_1 nrlc35_2 1
Crlc35 nrlc35_2 rlc5 8.70338490284e-14
* RLC[37] P2A-rlc7
Rrlc37 P2A nrlc37_1 130285.973253
Lrlc37 nrlc37_1 nrlc37_2 1
Crlc37 nrlc37_2 rlc7 6.54579149451e-14
* RLC[40] P2A-rlc10
Rrlc40 P2A nrlc40_1 127643.954132
Lrlc40 nrlc40_1 nrlc40_2 1
Crlc40 nrlc40_2 rlc10 6.8195700081e-14
* RLC[47] P3A-P4A
Rrlc47 P3A nrlc47_1 35.1193089556
Lrlc47 nrlc47_1 nrlc47_2 4.84337643542e-07
Crlc47 nrlc47_2 P4A 1.08973201148e-08
* RLC[48] P3A-P1B
Rrlc48 P3A nrlc48_1 1535.4949414
Lrlc48 nrlc48_1 nrlc48_2 1.01573884169e-05
Crlc48 nrlc48_2 P1B 3.74807213673e-11
* RLC[49] P3A-P2B
Rrlc49 P3A nrlc49_1 1.3229034132e+12
Lrlc49 nrlc49_1 nrlc49_2 0.000424166583271
Crlc49 nrlc49_2 P2B 2.65602528789e-06
* RLC[50] P3A-P3B
Rrlc50 P3A nrlc50_1 746.58535056
Lrlc50 nrlc50_1 nrlc50_2 7.26490566226e-06
Crlc50 nrlc50_2 P3B 2.0358710327e-11
* RLC[51] P3A-P4B
Rrlc51 P3A nrlc51_1 2.63770873769
Lrlc51 nrlc51_1 nrlc51_2 1.38835343523e-07
Crlc51 nrlc51_2 P4B 2.21719481232e-11
* RLC[60] P3A-rlc8
Rrlc60 P3A nrlc60_1 2570.21952808
Lrlc60 nrlc60_1 nrlc60_2 0.000446897035698
Crlc60 nrlc60_2 rlc8 7.51665342814e-14
* RLC[61] P3A-rlc9
Rrlc61 P3A nrlc61_1 87088.011802
Lrlc61 nrlc61_1 nrlc61_2 1
Crlc61 nrlc61_2 rlc9 1.46501050518e-13
* RLC[62] P3A-rlc10
Rrlc62 P3A nrlc62_1 10775.9365027
Lrlc62 nrlc62_1 nrlc62_2 0.00057749914896
Crlc62 nrlc62_2 rlc10 5.52584618398e-15
* RLC[64] P3A-rlc12
Rrlc64 P3A nrlc64_1 239564.320092
Lrlc64 nrlc64_1 nrlc64_2 1
Crlc64 nrlc64_2 rlc12 1.93603506209e-14
* RLC[65] P3A-rlc13
Rrlc65 P3A nrlc65_1 151425.515675
Lrlc65 nrlc65_1 nrlc65_2 1
Crlc65 nrlc65_2 rlc13 4.84573174036e-14
* RLC[69] P4A-P1B
Rrlc69 P4A nrlc69_1 0.01
Lrlc69 nrlc69_1 nrlc69_2 1.75321863392e-14
Crlc69 nrlc69_2 P1B 1.65915811197e-11
* RLC[70] P4A-P2B
Rrlc70 P4A nrlc70_1 25129.9425099
Lrlc70 nrlc70_1 nrlc70_2 3.64811284524e-05
Crlc70 nrlc70_2 P2B 1.88996701208e-06
* RLC[71] P4A-P3B
Rrlc71 P4A nrlc71_1 0.01
Lrlc71 nrlc71_1 nrlc71_2 1e-16
Crlc71 nrlc71_2 P3B 1.86760319138e-11
* RLC[72] P4A-P4B
Rrlc72 P4A nrlc72_1 24868.0982897
Lrlc72 nrlc72_1 nrlc72_2 3.18174271817e-05
Crlc72 nrlc72_2 P4B 1.91375492377e-06
* RLC[81] P4A-rlc8
Rrlc81 P4A nrlc81_1 8.65564898213
Lrlc81 nrlc81_1 nrlc81_2 3.69922807006e-10
Crlc81 nrlc81_2 rlc8 5.48617082946e-15
* RLC[88] P4A-rlc15
Rrlc88 P4A nrlc88_1 697802128317
Lrlc88 nrlc88_1 nrlc88_2 0.999922200096
Crlc88 nrlc88_2 rlc15 1.57009584529e-06
* RLC[91] P1B-P3B
Rrlc91 P1B nrlc91_1 0.01
Lrlc91 nrlc91_1 nrlc91_2 1.36954092302e-08
Crlc91 nrlc91_2 P3B 0.001
* RLC[94] P1B-rlc1
Rrlc94 P1B nrlc94_1 2085.3419871
Lrlc94 nrlc94_1 nrlc94_2 0.000243938273412
Crlc94 nrlc94_2 rlc1 6.23279525882e-14
* RLC[95] P1B-rlc2
Rrlc95 P1B nrlc95_1 111339.514162
Lrlc95 nrlc95_1 nrlc95_2 1
Crlc95 nrlc95_2 rlc2 8.96311248521e-14
* RLC[97] P1B-rlc4
Rrlc97 P1B nrlc97_1 98476.2130462
Lrlc97 nrlc97_1 nrlc97_2 1
Crlc97 nrlc97_2 rlc4 1.14576304906e-13
* RLC[99] P1B-rlc6
Rrlc99 P1B nrlc99_1 111765.874418
Lrlc99 nrlc99_1 nrlc99_2 1
Crlc99 nrlc99_2 rlc6 8.89485863097e-14
* RLC[103] P1B-rlc10
Rrlc103 P1B nrlc103_1 1344.38236377
Lrlc103 nrlc103_1 nrlc103_2 2.83991354412e-05
Crlc103 nrlc103_2 rlc10 1.74589047817e-14
* RLC[108] P1B-rlc15
Rrlc108 P1B nrlc108_1 337531.653493
Lrlc108 nrlc108_1 nrlc108_2 1
Crlc108 nrlc108_2 rlc15 9.75278110172e-15
* RLC[109] P1B-GND
Rrlc109 P1B nrlc109_1 857.948840945
Lrlc109 nrlc109_1 nrlc109_2 5.11323328916e-05
Crlc109 nrlc109_2 GND 7.71845389881e-14
* RLC[110] P2B-P3B
Rrlc110 P2B nrlc110_1 5.07694486716
Lrlc110 nrlc110_1 nrlc110_2 1.06810695783e-10
Crlc110 nrlc110_2 P3B 3.52924186244e-10
* RLC[111] P2B-P4B
Rrlc111 P2B nrlc111_1 0.01
Lrlc111 nrlc111_1 nrlc111_2 8.9867684264e-09
Crlc111 nrlc111_2 P4B 0.001
* RLC[114] P2B-rlc2
Rrlc114 P2B nrlc114_1 122567.642783
Lrlc114 nrlc114_1 nrlc114_2 1
Crlc114 nrlc114_2 rlc2 7.39615191508e-14
* RLC[116] P2B-rlc4
Rrlc116 P2B nrlc116_1 170439.177333
Lrlc116 nrlc116_1 nrlc116_2 1
Crlc116 nrlc116_2 rlc4 3.82488720074e-14
* RLC[117] P2B-rlc5
Rrlc117 P2B nrlc117_1 215523.642255
Lrlc117 nrlc117_1 nrlc117_2 1
Crlc117 nrlc117_2 rlc5 2.39203568845e-14
* RLC[118] P2B-rlc6
Rrlc118 P2B nrlc118_1 123283.218025
Lrlc118 nrlc118_1 nrlc118_2 1
Crlc118 nrlc118_2 rlc6 7.31054182825e-14
* RLC[119] P2B-rlc7
Rrlc119 P2B nrlc119_1 92645.3603616
Lrlc119 nrlc119_1 nrlc119_2 1
Crlc119 nrlc119_2 rlc7 1.29452410195e-13
* RLC[120] P2B-rlc8
Rrlc120 P2B nrlc120_1 0.274289019054
Lrlc120 nrlc120_1 nrlc120_2 3.25099459173e-12
Crlc120 nrlc120_2 rlc8 4.80127846498e-14
* RLC[122] P2B-rlc10
Rrlc122 P2B nrlc122_1 241054.916957
Lrlc122 nrlc122_1 nrlc122_2 1
Crlc122 nrlc122_2 rlc10 1.91216560273e-14
* RLC[124] P2B-rlc12
Rrlc124 P2B nrlc124_1 214292.012946
Lrlc124 nrlc124_1 nrlc124_2 1
Crlc124 nrlc124_2 rlc12 2.41961084146e-14
* RLC[125] P2B-rlc13
Rrlc125 P2B nrlc125_1 269979.337401
Lrlc125 nrlc125_1 nrlc125_2 1
Crlc125 nrlc125_2 rlc13 1.5243912115e-14
* RLC[126] P2B-rlc14
Rrlc126 P2B nrlc126_1 133026.802606
Lrlc126 nrlc126_1 nrlc126_2 1
Crlc126 nrlc126_2 rlc14 6.2788366599e-14
* RLC[127] P2B-rlc15
Rrlc127 P2B nrlc127_1 0.0130760813138
Lrlc127 nrlc127_1 nrlc127_2 5.14709854797e-13
Crlc127 nrlc127_2 rlc15 3.34475836743e-12
* RLC[130] P3B-rlc0
Rrlc130 P3B nrlc130_1 191793.648342
Lrlc130 nrlc130_1 nrlc130_2 1
Crlc130 nrlc130_2 rlc0 3.02057100773e-14
* RLC[132] P3B-rlc2
Rrlc132 P3B nrlc132_1 268726.636146
Lrlc132 nrlc132_1 nrlc132_2 1
Crlc132 nrlc132_2 rlc2 1.53863660034e-14
* RLC[134] P3B-rlc4
Rrlc134 P3B nrlc134_1 1.6968790467e+12
Lrlc134 nrlc134_1 nrlc134_2 1
Crlc134 nrlc134_2 rlc4 7.53534431369e-08
* RLC[139] P3B-rlc9
Rrlc139 P3B nrlc139_1 270015.373999
Lrlc139 nrlc139_1 nrlc139_2 1
Crlc139 nrlc139_2 rlc9 1.52398434423e-14
* RLC[141] P3B-rlc11
Rrlc141 P3B nrlc141_1 214292.1742
Lrlc141 nrlc141_1 nrlc141_2 1
Crlc141 nrlc141_2 rlc11 2.41960719997e-14
* RLC[144] P3B-rlc14
Rrlc144 P3B nrlc144_1 133026.785659
Lrlc144 nrlc144_1 nrlc144_2 1
Crlc144 nrlc144_2 rlc14 6.27883825971e-14
* RLC[146] P3B-GND
Rrlc146 P3B nrlc146_1 301258.740486
Lrlc146 nrlc146_1 nrlc146_2 1
Crlc146 nrlc146_2 GND 1.22427273715e-14
* RLC[149] P4B-rlc2
Rrlc149 P4B nrlc149_1 122567.334924
Lrlc149 nrlc149_1 nrlc149_2 1
Crlc149 nrlc149_2 rlc2 7.39618906985e-14
* RLC[152] P4B-rlc5
Rrlc152 P4B nrlc152_1 73662.0526536
Lrlc152 nrlc152_1 nrlc152_2 1
Crlc152 nrlc152_2 rlc5 2.04771662966e-13
* RLC[155] P4B-rlc8
Rrlc155 P4B nrlc155_1 170398.426145
Lrlc155 nrlc155_1 nrlc155_2 1
Crlc155 nrlc155_2 rlc8 3.82671688117e-14
* RLC[156] P4B-rlc9
Rrlc156 P4B nrlc156_1 87110.5446917
Lrlc156 nrlc156_1 nrlc156_2 1
Crlc156 nrlc156_2 rlc9 1.4642526945e-13
* RLC[157] P4B-rlc10
Rrlc157 P4B nrlc157_1 192640.228059
Lrlc157 nrlc157_1 nrlc157_2 1
Crlc157 nrlc157_2 rlc10 2.99408084709e-14
* RLC[161] P4B-rlc14
Rrlc161 P4B nrlc161_1 133026.757311
Lrlc161 nrlc161_1 nrlc161_2 1
Crlc161 nrlc161_2 rlc14 6.27884093571e-14
* RLC[162] P4B-rlc15
Rrlc162 P4B nrlc162_1 301258.618994
Lrlc162 nrlc162_1 nrlc162_2 1
Crlc162 nrlc162_2 rlc15 1.22427372461e-14
* RLC[164] rlc0-rlc1
Rrlc164 rlc0 nrlc164_1 0.0939129868473
Lrlc164 nrlc164_1 nrlc164_2 0.00190781301015
Crlc164 nrlc164_2 rlc1 0.000240348817715
* RLC[165] rlc0-rlc2
Rrlc165 rlc0 nrlc165_1 1.44172415711
Lrlc165 nrlc165_1 nrlc165_2 1
Crlc165 nrlc165_2 rlc2 0.000534555915264
* RLC[166] rlc0-rlc3
Rrlc166 rlc0 nrlc166_1 122.03143552
Lrlc166 nrlc166_1 nrlc166_2 1
Crlc166 nrlc166_2 rlc3 7.46129223566e-08
* RLC[167] rlc0-rlc4
Rrlc167 rlc0 nrlc167_1 138.862032035
Lrlc167 nrlc167_1 nrlc167_2 0.000900505037638
Crlc167 nrlc167_2 rlc4 5.18891557725e-11
* RLC[168] rlc0-rlc5
Rrlc168 rlc0 nrlc168_1 48637.1026784
Lrlc168 nrlc168_1 nrlc168_2 1
Crlc168 nrlc168_2 rlc5 4.69701663733e-13
* RLC[169] rlc0-rlc6
Rrlc169 rlc0 nrlc169_1 30.1766443005
Lrlc169 nrlc169_1 nrlc169_2 0.128165636431
Crlc169 nrlc169_2 rlc6 1.56382157848e-07
* RLC[170] rlc0-rlc7
Rrlc170 rlc0 nrlc170_1 10.5006877047
Lrlc170 nrlc170_1 nrlc170_2 1
Crlc170 nrlc170_2 rlc7 1.00767853011e-05
* RLC[171] rlc0-rlc8
Rrlc171 rlc0 nrlc171_1 1.83691549051
Lrlc171 nrlc171_1 nrlc171_2 0.227816321314
Crlc171 nrlc171_2 rlc8 7.50177392925e-05
* RLC[172] rlc0-rlc9
Rrlc172 rlc0 nrlc172_1 33.3807238854
Lrlc172 nrlc172_1 nrlc172_2 1
Crlc172 nrlc172_2 rlc9 9.97162619234e-07
* RLC[173] rlc0-rlc10
Rrlc173 rlc0 nrlc173_1 28.078120554
Lrlc173 nrlc173_1 nrlc173_2 1
Crlc173 nrlc173_2 rlc10 1.40935831418e-06
* RLC[176] rlc0-rlc13
Rrlc176 rlc0 nrlc176_1 2005.83602426
Lrlc176 nrlc176_1 nrlc176_2 1
Crlc176 nrlc176_2 rlc13 2.76163728083e-10
* RLC[179] rlc0-GND
Rrlc179 rlc0 nrlc179_1 0.973604860069
Lrlc179 nrlc179_1 nrlc179_2 0.107358929988
Crlc179 nrlc179_2 GND 0.000125843329071
* RLC[182] rlc1-rlc4
Rrlc182 rlc1 nrlc182_1 2386.48887443
Lrlc182 nrlc182_1 nrlc182_2 0.000357619273313
Crlc182 nrlc182_2 rlc4 6.97685309863e-14
* RLC[183] rlc1-rlc5
Rrlc183 rlc1 nrlc183_1 3958.6653023
Lrlc183 nrlc183_1 nrlc183_2 1
Crlc183 nrlc183_2 rlc5 7.09022343735e-11
* RLC[184] rlc1-rlc6
Rrlc184 rlc1 nrlc184_1 8.40392170659
Lrlc184 nrlc184_1 nrlc184_2 1
Crlc184 nrlc184_2 rlc6 1.57323462118e-05
* RLC[187] rlc1-rlc9
Rrlc187 rlc1 nrlc187_1 284.866260631
Lrlc187 nrlc187_1 nrlc187_2 1
Crlc187 nrlc187_2 rlc9 1.36922702085e-08
* RLC[188] rlc1-rlc10
Rrlc188 rlc1 nrlc188_1 249.868631211
Lrlc188 nrlc188_1 nrlc188_2 1
Crlc188 nrlc188_2 rlc10 1.77964760759e-08
* RLC[189] rlc1-rlc11
Rrlc189 rlc1 nrlc189_1 9.78654039426
Lrlc189 nrlc189_1 nrlc189_2 0.00266946687975
Crlc189 nrlc189_2 rlc11 3.0968747525e-08
* RLC[190] rlc1-rlc12
Rrlc190 rlc1 nrlc190_1 1.56939582782
Lrlc190 nrlc190_1 nrlc190_2 0.121786342184
Crlc190 nrlc190_2 rlc12 5.49403080129e-05
* RLC[191] rlc1-rlc13
Rrlc191 rlc1 nrlc191_1 3686.41684418
Lrlc191 nrlc191_1 nrlc191_2 1
Crlc191 nrlc191_2 rlc13 8.1761454155e-11
* RLC[195] rlc2-rlc3
Rrlc195 rlc2 nrlc195_1 0.120040504228
Lrlc195 nrlc195_1 nrlc195_2 0.0129686110996
Crlc195 nrlc195_2 rlc3 0.000999989259557
* RLC[197] rlc2-rlc5
Rrlc197 rlc2 nrlc197_1 1.25754728525
Lrlc197 nrlc197_1 nrlc197_2 1
Crlc197 nrlc197_2 rlc5 0.000702601127725
* RLC[198] rlc2-rlc6
Rrlc198 rlc2 nrlc198_1 22.8200531603
Lrlc198 nrlc198_1 nrlc198_2 0.00651962278004
Crlc198 nrlc198_2 rlc6 1.39106253964e-08
* RLC[199] rlc2-rlc7
Rrlc199 rlc2 nrlc199_1 7.64393908241
Lrlc199 nrlc199_1 nrlc199_2 1
Crlc199 nrlc199_2 rlc7 1.90161702046e-05
* RLC[200] rlc2-rlc8
Rrlc200 rlc2 nrlc200_1 43.9084615333
Lrlc200 nrlc200_1 nrlc200_2 0.0631103966325
Crlc200 nrlc200_2 rlc8 3.63715625511e-08
* RLC[203] rlc2-rlc11
Rrlc203 rlc2 nrlc203_1 235.753811327
Lrlc203 nrlc203_1 nrlc203_2 0.00052241714854
Crlc203 nrlc203_2 rlc11 1.04437741121e-11
* RLC[205] rlc2-rlc13
Rrlc205 rlc2 nrlc205_1 2756.99712183
Lrlc205 nrlc205_1 nrlc205_2 1
Crlc205 nrlc205_2 rlc13 1.46178959115e-10
* RLC[206] rlc2-rlc14
Rrlc206 rlc2 nrlc206_1 688.70481185
Lrlc206 nrlc206_1 nrlc206_2 1
Crlc206 nrlc206_2 rlc14 2.34256287289e-09
* RLC[208] rlc2-GND
Rrlc208 rlc2 nrlc208_1 1.66154901097
Lrlc208 nrlc208_1 nrlc208_2 1
Crlc208 nrlc208_2 GND 0.000402467835489
* RLC[209] rlc3-rlc4
Rrlc209 rlc3 nrlc209_1 9.40430836501
Lrlc209 nrlc209_1 nrlc209_2 1
Crlc209 nrlc209_2 rlc4 1.25633010968e-05
* RLC[210] rlc3-rlc5
Rrlc210 rlc3 nrlc210_1 4553.63105229
Lrlc210 nrlc210_1 nrlc210_2 1
Crlc210 nrlc210_2 rlc5 5.35848242482e-11
* RLC[211] rlc3-rlc6
Rrlc211 rlc3 nrlc211_1 8.52480957125
Lrlc211 nrlc211_1 nrlc211_2 0.223196894672
Crlc211 nrlc211_2 rlc6 3.4125283318e-06
* RLC[213] rlc3-rlc8
Rrlc213 rlc3 nrlc213_1 63.4468815036
Lrlc213 nrlc213_1 nrlc213_2 0.0425344774492
Crlc213 nrlc213_2 rlc8 1.1740268535e-08
* RLC[214] rlc3-rlc9
Rrlc214 rlc3 nrlc214_1 73.1098499153
Lrlc214 nrlc214_1 nrlc214_2 0.0564386218144
Crlc214 nrlc214_2 rlc9 1.17322715371e-08
* RLC[215] rlc3-rlc10
Rrlc215 rlc3 nrlc215_1 22.6567733111
Lrlc215 nrlc215_1 nrlc215_2 1
Crlc215 nrlc215_2 rlc10 2.16451884731e-06
* RLC[216] rlc3-rlc11
Rrlc216 rlc3 nrlc216_1 233.686559569
Lrlc216 nrlc216_1 nrlc216_2 1
Crlc216 nrlc216_2 rlc11 2.03465144432e-08
* RLC[217] rlc3-rlc12
Rrlc217 rlc3 nrlc217_1 691.565545241
Lrlc217 nrlc217_1 nrlc217_2 1
Crlc217 nrlc217_2 rlc12 2.32322244375e-09
* RLC[220] rlc3-rlc15
Rrlc220 rlc3 nrlc220_1 2313.11909854
Lrlc220 nrlc220_1 nrlc220_2 1
Crlc220 nrlc220_2 rlc15 2.07664137052e-10
* RLC[221] rlc3-GND
Rrlc221 rlc3 nrlc221_1 1.28049677171
Lrlc221 nrlc221_1 nrlc221_2 1
Crlc221 nrlc221_2 GND 0.000677642310821
* RLC[222] rlc4-rlc5
Rrlc222 rlc4 nrlc222_1 9920.88069921
Lrlc222 nrlc222_1 nrlc222_2 0.00102310405094
Crlc222 nrlc222_2 rlc5 1.15498632027e-14
* RLC[223] rlc4-rlc6
Rrlc223 rlc4 nrlc223_1 3.31945225788
Lrlc223 nrlc223_1 nrlc223_2 5.94667072665e-09
Crlc223 nrlc223_2 rlc6 5.99650953849e-13
* RLC[224] rlc4-rlc7
Rrlc224 rlc4 nrlc224_1 39.7305082969
Lrlc224 nrlc224_1 nrlc224_2 1
Crlc224 nrlc224_2 rlc7 7.03897216755e-07
* RLC[225] rlc4-rlc8
Rrlc225 rlc4 nrlc225_1 1.06213797554
Lrlc225 nrlc225_1 nrlc225_2 0.579028853808
Crlc225 nrlc225_2 rlc8 0.000570290087122
* RLC[226] rlc4-rlc9
Rrlc226 rlc4 nrlc226_1 4.7740854089
Lrlc226 nrlc226_1 nrlc226_2 1
Crlc226 nrlc226_2 rlc9 4.87502808413e-05
* RLC[227] rlc4-rlc10
Rrlc227 rlc4 nrlc227_1 54885.994409
Lrlc227 nrlc227_1 nrlc227_2 1
Crlc227 nrlc227_2 rlc10 3.68836945245e-13
* RLC[228] rlc4-rlc11
Rrlc228 rlc4 nrlc228_1 280.313915217
Lrlc228 nrlc228_1 nrlc228_2 0.0512737071875
Crlc228 nrlc228_2 rlc11 7.25041548903e-10
* RLC[229] rlc4-rlc12
Rrlc229 rlc4 nrlc229_1 0.21546086259
Lrlc229 nrlc229_1 nrlc229_2 0.000634573520869
Crlc229 nrlc229_2 rlc12 1.51880720363e-05
* RLC[230] rlc4-rlc13
Rrlc230 rlc4 nrlc230_1 476.656538334
Lrlc230 nrlc230_1 nrlc230_2 0.749795169304
Crlc230 nrlc230_2 rlc13 3.66681516941e-09
* RLC[231] rlc4-rlc14
Rrlc231 rlc4 nrlc231_1 0.0446039198827
Lrlc231 nrlc231_1 nrlc231_2 8.93654456447e-12
Crlc231 nrlc231_2 rlc14 4.99092520922e-12
* RLC[232] rlc4-rlc15
Rrlc232 rlc4 nrlc232_1 22.0501356498
Lrlc232 nrlc232_1 nrlc232_2 0.00971563811361
Crlc232 nrlc232_2 rlc15 2.22027254877e-08
* RLC[234] rlc5-rlc6
Rrlc234 rlc5 nrlc234_1 253.556365396
Lrlc234 nrlc234_1 nrlc234_2 1
Crlc234 nrlc234_2 rlc6 1.7282575192e-08
* RLC[236] rlc5-rlc8
Rrlc236 rlc5 nrlc236_1 1.5474705267
Lrlc236 nrlc236_1 nrlc236_2 1
Crlc236 nrlc236_2 rlc8 0.000463994377803
* RLC[237] rlc5-rlc9
Rrlc237 rlc5 nrlc237_1 27.284114775
Lrlc237 nrlc237_1 nrlc237_2 1
Crlc237 nrlc237_2 rlc9 1.49258047095e-06
* RLC[238] rlc5-rlc10
Rrlc238 rlc5 nrlc238_1 14.297800415
Lrlc238 nrlc238_1 nrlc238_2 0.000297308495202
Crlc238 nrlc238_2 rlc10 1.61594415696e-09
* RLC[239] rlc5-rlc11
Rrlc239 rlc5 nrlc239_1 20.2824470357
Lrlc239 nrlc239_1 nrlc239_2 1
Crlc239 nrlc239_2 rlc11 2.70095152267e-06
* RLC[240] rlc5-rlc12
Rrlc240 rlc5 nrlc240_1 2.11558734404
Lrlc240 nrlc240_1 nrlc240_2 1
Crlc240 nrlc240_2 rlc12 0.000248253608526
* RLC[241] rlc5-rlc13
Rrlc241 rlc5 nrlc241_1 104.145132237
Lrlc241 nrlc241_1 nrlc241_2 1
Crlc241 nrlc241_2 rlc13 1.02442351545e-07
* RLC[242] rlc5-rlc14
Rrlc242 rlc5 nrlc242_1 1.36535191809
Lrlc242 nrlc242_1 nrlc242_2 0.0438802571515
Crlc242 nrlc242_2 rlc14 2.61539593875e-05
* RLC[243] rlc5-rlc15
Rrlc243 rlc5 nrlc243_1 330.063572882
Lrlc243 nrlc243_1 nrlc243_2 1
Crlc243 nrlc243_2 rlc15 1.01991105103e-08
* RLC[244] rlc5-GND
Rrlc244 rlc5 nrlc244_1 24.9756364559
Lrlc244 nrlc244_1 nrlc244_2 1
Crlc244 nrlc244_2 GND 1.78124788698e-06
* RLC[245] rlc6-rlc7
Rrlc245 rlc6 nrlc245_1 3.07383682362
Lrlc245 nrlc245_1 nrlc245_2 1
Crlc245 nrlc245_2 rlc7 0.000117596899783
* RLC[247] rlc6-rlc9
Rrlc247 rlc6 nrlc247_1 0.475672754869
Lrlc247 nrlc247_1 nrlc247_2 3.81704118588e-08
Crlc247 nrlc247_2 rlc9 1.87442376787e-10
* RLC[248] rlc6-rlc10
Rrlc248 rlc6 nrlc248_1 1808.46124824
Lrlc248 nrlc248_1 nrlc248_2 1
Crlc248 nrlc248_2 rlc10 3.39734049922e-10
* RLC[249] rlc6-rlc11
Rrlc249 rlc6 nrlc249_1 4646.21583776
Lrlc249 nrlc249_1 nrlc249_2 1
Crlc249 nrlc249_2 rlc11 5.14705404928e-11
* RLC[254] rlc6-GND
Rrlc254 rlc6 nrlc254_1 17.370506482
Lrlc254 nrlc254_1 nrlc254_2 0.887553737936
Crlc254 nrlc254_2 GND 3.26833966559e-06
* RLC[255] rlc7-rlc8
Rrlc255 rlc7 nrlc255_1 5444.33712637
Lrlc255 nrlc255_1 nrlc255_2 1
Crlc255 nrlc255_2 rlc8 3.74858592969e-11
* RLC[256] rlc7-rlc9
Rrlc256 rlc7 nrlc256_1 8.35826561823
Lrlc256 nrlc256_1 nrlc256_2 1
Crlc256 nrlc256_2 rlc9 1.59046879813e-05
* RLC[257] rlc7-rlc10
Rrlc257 rlc7 nrlc257_1 396144.403111
Lrlc257 nrlc257_1 nrlc257_2 1
Crlc257 nrlc257_2 rlc10 7.08028014492e-15
* RLC[258] rlc7-rlc11
Rrlc258 rlc7 nrlc258_1 6.61406717321
Lrlc258 nrlc258_1 nrlc258_2 1
Crlc258 nrlc258_2 rlc11 2.5399214623e-05
* RLC[260] rlc7-rlc13
Rrlc260 rlc7 nrlc260_1 28.2310811981
Lrlc260 nrlc260_1 nrlc260_2 1
Crlc260 nrlc260_2 rlc13 1.39412741743e-06
* RLC[262] rlc7-rlc15
Rrlc262 rlc7 nrlc262_1 108.305451346
Lrlc262 nrlc262_1 nrlc262_2 1
Crlc262 nrlc262_2 rlc15 9.47233082293e-08
* RLC[265] rlc8-rlc10
Rrlc265 rlc8 nrlc265_1 3.10962813663
Lrlc265 nrlc265_1 nrlc265_2 1
Crlc265 nrlc265_2 rlc10 0.000114905436292
* RLC[266] rlc8-rlc11
Rrlc266 rlc8 nrlc266_1 30.5576881575
Lrlc266 nrlc266_1 nrlc266_2 0.918502134938
Crlc266 nrlc266_2 rlc11 1.09294088255e-06
* RLC[268] rlc8-rlc13
Rrlc268 rlc8 nrlc268_1 7.76508491837
Lrlc268 nrlc268_1 nrlc268_2 0.000314942870274
Crlc268 nrlc268_2 rlc13 5.80359172407e-09
* RLC[269] rlc8-rlc14
Rrlc269 rlc8 nrlc269_1 7.34461150732
Lrlc269 nrlc269_1 nrlc269_2 0.3167221153
Crlc269 nrlc269_2 rlc14 6.52376370662e-06
* RLC[271] rlc8-GND
Rrlc271 rlc8 nrlc271_1 1.01982392665
Lrlc271 nrlc271_1 nrlc271_2 0.9360131356
Crlc271 nrlc271_2 GND 0.000999974764215
* RLC[272] rlc9-rlc10
Rrlc272 rlc9 nrlc272_1 8.27421660586
Lrlc272 nrlc272_1 nrlc272_2 1
Crlc272 nrlc272_2 rlc10 1.62294468833e-05
* RLC[273] rlc9-rlc11
Rrlc273 rlc9 nrlc273_1 30512.431424
Lrlc273 nrlc273_1 nrlc273_2 0.00362064150761
Crlc273 nrlc273_2 rlc11 4.3210509163e-15
* RLC[275] rlc9-rlc13
Rrlc275 rlc9 nrlc275_1 5.30420275978
Lrlc275 nrlc275_1 nrlc275_2 7.19514906718e-07
Crlc275 nrlc275_2 rlc13 2.8415614494e-11
* RLC[276] rlc9-rlc14
Rrlc276 rlc9 nrlc276_1 1238.89840452
Lrlc276 nrlc276_1 nrlc276_2 0.732866810583
Crlc276 nrlc276_2 rlc14 5.30531478587e-10
* RLC[277] rlc9-rlc15
Rrlc277 rlc9 nrlc277_1 204.653846441
Lrlc277 nrlc277_1 nrlc277_2 1
Crlc277 nrlc277_2 rlc15 2.65288037763e-08
* RLC[278] rlc9-GND
Rrlc278 rlc9 nrlc278_1 1910.6497765
Lrlc278 nrlc278_1 nrlc278_2 1
Crlc278 nrlc278_2 GND 3.04365423951e-10
* RLC[279] rlc10-rlc11
Rrlc279 rlc10 nrlc279_1 1.11624851629
Lrlc279 nrlc279_1 nrlc279_2 1
Crlc279 nrlc279_2 rlc11 0.000891734771153
* RLC[280] rlc10-rlc12
Rrlc280 rlc10 nrlc280_1 1.505020156
Lrlc280 nrlc280_1 nrlc280_2 1
Crlc280 nrlc280_2 rlc12 0.000490538228132
* RLC[282] rlc10-rlc14
Rrlc282 rlc10 nrlc282_1 5.23353348768
Lrlc282 nrlc282_1 nrlc282_2 0.0375061800978
Crlc282 nrlc282_2 rlc14 1.52149423245e-06
* RLC[284] rlc10-GND
Rrlc284 rlc10 nrlc284_1 1.14650143631
Lrlc284 nrlc284_1 nrlc284_2 1
Crlc284 nrlc284_2 GND 0.00084529496923
* RLC[286] rlc11-rlc13
Rrlc286 rlc11 nrlc286_1 18.1173829242
Lrlc286 nrlc286_1 nrlc286_2 0.896425771247
Crlc286 nrlc286_2 rlc13 3.03445636631e-06
* RLC[287] rlc11-rlc14
Rrlc287 rlc11 nrlc287_1 395.415240207
Lrlc287 nrlc287_1 nrlc287_2 0.619297649097
Crlc287 nrlc287_2 rlc14 4.40098728622e-09
* RLC[288] rlc11-rlc15
Rrlc288 rlc11 nrlc288_1 0.01
Lrlc288 nrlc288_1 nrlc288_2 1.47742616375e-06
Crlc288 nrlc288_2 rlc15 0.000173903477994
* RLC[289] rlc11-GND
Rrlc289 rlc11 nrlc289_1 0.01
Lrlc289 nrlc289_1 nrlc289_2 8.59729955208e-12
Crlc289 nrlc289_2 GND 2.13425533885e-08
* RLC[290] rlc12-rlc13
Rrlc290 rlc12 nrlc290_1 2579.31745748
Lrlc290 nrlc290_1 nrlc290_2 1
Crlc290 nrlc290_2 rlc13 1.6701208407e-10
* RLC[293] rlc12-GND
Rrlc293 rlc12 nrlc293_1 0.0103400791751
Lrlc293 nrlc293_1 nrlc293_2 1.46767694883e-09
Crlc293 nrlc293_2 GND 1.52524719663e-08
* RLC[294] rlc13-rlc14
Rrlc294 rlc13 nrlc294_1 6.12666713105
Lrlc294 nrlc294_1 nrlc294_2 0.241486892163
Crlc294 nrlc294_2 rlc14 7.14829525503e-06
* RLC[297] rlc14-rlc15
Rrlc297 rlc14 nrlc297_1 0.142608150335
Lrlc297 nrlc297_1 nrlc297_2 1.43229371408e-11
Crlc297 nrlc297_2 rlc15 7.82529795167e-13
* RLC[299] rlc15-GND
Rrlc299 rlc15 nrlc299_1 253.119976336
Lrlc299 nrlc299_1 nrlc299_2 0.000750015411741
Crlc299 nrlc299_2 GND 1.30069309809e-11
* DC[0] P1A-P2A
Rdc0 P1A ndc0_1 0.0859437333516
Ldc0 ndc0_1 P2A 1.06511068158e-07
* DC[3] P1A-P1B
Rdc3 P1A ndc3_1 880026725316
Ldc3 ndc3_1 P1B 1
* DC[13] P2A-P4A
Rdc13 P2A ndc13_1 1.45383726144e+12
Ldc13 ndc13_1 P4A 1
* DC[14] P2A-P1B
Rdc14 P2A ndc14_1 126.464090782
Ldc14 ndc14_1 P1B 0.00102200462611
* DC[16] P2A-P3B
Rdc16 P2A ndc16_1 135.671189908
Ldc16 ndc16_1 P3B 2.15927405089e-05
* DC[18] P2A-dc0
Rdc18 P2A ndc18_1 493531244.809
Ldc18 ndc18_1 dc0 1
* DC[19] P2A-dc1
Rdc19 P2A ndc19_1 662967856.615
Ldc19 ndc19_1 dc1 1
* DC[21] P2A-dc3
Rdc21 P2A ndc21_1 523544239.722
Ldc21 ndc21_1 dc3 1
* DC[23] P3A-P4A
Rdc23 P3A ndc23_1 1.08806180549
Ldc23 ndc23_1 P4A 4.00834122924e-07
* DC[30] P3A-dc2
Rdc30 P3A ndc30_1 17202.4985053
Ldc30 ndc30_1 dc2 0.00273786267065
* DC[31] P3A-dc3
Rdc31 P3A ndc31_1 20184.3652179
Ldc31 ndc31_1 dc3 0.00321244149759
* DC[33] P4A-P1B
Rdc33 P4A ndc33_1 39211.7801131
Ldc33 ndc33_1 P1B 0.00624074863243
* DC[35] P4A-P3B
Rdc35 P4A ndc35_1 39195.3598308
Ldc35 ndc35_1 P3B 0.00623813526333
* DC[38] P4A-dc1
Rdc38 P4A ndc38_1 27038961356.3
Ldc38 ndc38_1 dc1 1
* DC[42] P1B-P2B
Rdc42 P1B ndc42_1 0.0145429626413
Ldc42 ndc42_1 P2B 8.92829466473e-07
* DC[43] P1B-P3B
Rdc43 P1B ndc43_1 0.01
Ldc43 ndc43_1 P3B 9.37056897108e-09
* DC[44] P1B-P4B
Rdc44 P1B ndc44_1 0.01
Ldc44 ndc44_1 P4B 6.51151963408e-07
* DC[45] P1B-dc0
Rdc45 P1B ndc45_1 0.0610443779292
Ldc45 ndc45_1 dc0 9.7155144954e-09
* DC[46] P1B-dc1
Rdc46 P1B ndc46_1 0.01
Ldc46 ndc46_1 dc1 3.02148422082e-08
* DC[47] P1B-dc2
Rdc47 P1B ndc47_1 0.01
Ldc47 ndc47_1 dc2 7.14442313296e-07
* DC[48] P1B-dc3
Rdc48 P1B ndc48_1 0.01
Ldc48 ndc48_1 dc3 2.2267265203e-08
* DC[50] P2B-P3B
Rdc50 P2B ndc50_1 0.01
Ldc50 ndc50_1 P3B 5.02657715772e-07
* DC[51] P2B-P4B
Rdc51 P2B ndc51_1 0.01
Ldc51 ndc51_1 P4B 6.70718374208e-09
* DC[52] P2B-dc0
Rdc52 P2B ndc52_1 0.01
Ldc52 ndc52_1 dc0 1.14354942466e-07
* DC[53] P2B-dc1
Rdc53 P2B ndc53_1 0.0142273726221
Ldc53 ndc53_1 dc1 1.7869291659e-06
* DC[54] P2B-dc2
Rdc54 P2B ndc54_1 0.01
Ldc54 ndc54_1 dc2 1.59154943092e-09
* DC[55] P2B-dc3
Rdc55 P2B ndc55_1 0.01
Ldc55 ndc55_1 dc3 1.42066050061e-06
* DC[57] P3B-P4B
Rdc57 P3B ndc57_1 0.01
Ldc57 ndc57_1 P4B 3.68430673839e-08
* DC[58] P3B-dc0
Rdc58 P3B ndc58_1 0.01
Ldc58 ndc58_1 dc0 1.4635513518e-07
* DC[59] P3B-dc1
Rdc59 P3B ndc59_1 0.01
Ldc59 ndc59_1 dc1 1.59154943092e-09
* DC[60] P3B-dc2
Rdc60 P3B ndc60_1 0.01
Ldc60 ndc60_1 dc2 9.94315629919e-07
* DC[61] P3B-dc3
Rdc61 P3B ndc61_1 0.01
Ldc61 ndc61_1 dc3 1.59154943092e-09
* DC[63] P4B-dc0
Rdc63 P4B ndc63_1 0.01
Ldc63 ndc63_1 dc0 1.75593625695e-06
* DC[64] P4B-dc1
Rdc64 P4B ndc64_1 0.01
Ldc64 ndc64_1 dc1 2.60542149399e-07
* DC[65] P4B-dc2
Rdc65 P4B ndc65_1 0.01
Ldc65 ndc65_1 dc2 3.23469296079e-08
* DC[66] P4B-dc3
Rdc66 P4B ndc66_1 0.01
Ldc66 ndc66_1 dc3 3.68578395599e-07
* DC[68] dc0-dc1
Rdc68 dc0 ndc68_1 0.01
Ldc68 ndc68_1 dc1 2.97766571741e-06
* ---- leaks
Rleak_P1A P1A GND 1e+12
Rleak_P1B P1B GND 1e+12
Rleak_P2A P2A GND 1e+12
Rleak_P2B P2B GND 1e+12
Rleak_P3A P3A GND 1e+12
Rleak_P3B P3B GND 1e+12
Rleak_P4A P4A GND 1e+12
Rleak_P4B P4B GND 1e+12
Rleak_dc0 dc0 GND 1e+12
Rleak_dc1 dc1 GND 1e+12
Rleak_dc2 dc2 GND 1e+12
Rleak_dc3 dc3 GND 1e+12
Rleak_rlc0 rlc0 GND 1e+12
Rleak_rlc1 rlc1 GND 1e+12
Rleak_rlc10 rlc10 GND 1e+12
Rleak_rlc11 rlc11 GND 1e+12
Rleak_rlc12 rlc12 GND 1e+12
Rleak_rlc13 rlc13 GND 1e+12
Rleak_rlc14 rlc14 GND 1e+12
Rleak_rlc15 rlc15 GND 1e+12
Rleak_rlc2 rlc2 GND 1e+12
Rleak_rlc3 rlc3 GND 1e+12
Rleak_rlc4 rlc4 GND 1e+12
Rleak_rlc5 rlc5 GND 1e+12
Rleak_rlc6 rlc6 GND 1e+12
Rleak_rlc7 rlc7 GND 1e+12
Rleak_rlc8 rlc8 GND 1e+12
Rleak_rlc9 rlc9 GND 1e+12
.ends fitted
