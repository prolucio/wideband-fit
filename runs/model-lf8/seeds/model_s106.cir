* fitted: 8-port fitted model, reference z0 = 50 Ohm
* every pin is a port against GND
.subckt fitted P1A P1B P2A P2B P3A P3B P4A P4B GND
* ---- branches
* RLC[0] P1A-P2A
Rrlc0 P1A nrlc0_1 0.105068521024
Lrlc0 nrlc0_1 nrlc0_2 1.63759210807e-07
Crlc0 nrlc0_2 P2A 0.001
* RLC[1] P1A-P3A
Rrlc1 P1A nrlc1_1 8566.03921399
Lrlc1 nrlc1_1 nrlc1_2 1.56185881818e-12
Crlc1 nrlc1_2 P3A 1.06744605786e-07
* RLC[2] P1A-P4A
Rrlc2 P1A nrlc2_1 8823.59677113
Lrlc2 nrlc2_1 nrlc2_2 3.1203077217e-05
Crlc2 nrlc2_2 P4A 1.06669100156e-07
* RLC[3] P1A-P1B
Rrlc3 P1A nrlc3_1 295.862316231
Lrlc3 nrlc3_1 nrlc3_2 2.23364382163e-06
Crlc3 nrlc3_2 P1B 7.43976032069e-11
* RLC[4] P1A-P2B
Rrlc4 P1A nrlc4_1 25632.6302601
Lrlc4 nrlc4_1 nrlc4_2 1.94758828639e-11
Crlc4 nrlc4_2 P2B 0.001
* RLC[5] P1A-P3B
Rrlc5 P1A nrlc5_1 474.945761656
Lrlc5 nrlc5_1 nrlc5_2 3.74031388022e-06
Crlc5 nrlc5_2 P3B 8.87427782818e-11
* RLC[6] P1A-P4B
Rrlc6 P1A nrlc6_1 14.9667772402
Lrlc6 nrlc6_1 nrlc6_2 1.68210362781e-15
Crlc6 nrlc6_2 P4B 4.29098160775e-11
* RLC[8] P1A-rlc1
Rrlc8 P1A nrlc8_1 271009.097881
Lrlc8 nrlc8_1 nrlc8_2 1
Crlc8 nrlc8_2 rlc1 1.51282868085e-14
* RLC[21] P1A-rlc14
Rrlc21 P1A nrlc21_1 3.16786063138e+12
Lrlc21 nrlc21_1 nrlc21_2 0.999994715487
Crlc21 nrlc21_2 rlc14 5.9621160737e-05
* RLC[23] P1A-GND
Rrlc23 P1A nrlc23_1 2.94998526078e+12
Lrlc23 nrlc23_1 nrlc23_2 0.0136670658178
Crlc23 nrlc23_2 GND 3.45089407347e-05
* RLC[24] P2A-P3A
Rrlc24 P2A nrlc24_1 37320.6295005
Lrlc24 nrlc24_1 nrlc24_2 7.59362910384e-05
Crlc24 nrlc24_2 P3A 0.001
* RLC[25] P2A-P4A
Rrlc25 P2A nrlc25_1 8586.50445709
Lrlc25 nrlc25_1 nrlc25_2 1.50956497366e-12
Crlc25 nrlc25_2 P4A 1.06886168743e-07
* RLC[26] P2A-P1B
Rrlc26 P2A nrlc26_1 59.488835238
Lrlc26 nrlc26_1 nrlc26_2 4.8017150917e-14
Crlc26 nrlc26_2 P1B 5.0367260244e-11
* RLC[27] P2A-P2B
Rrlc27 P2A nrlc27_1 261.436936031
Lrlc27 nrlc27_1 nrlc27_2 1.94581599182e-06
Crlc27 nrlc27_2 P2B 7.11952337626e-11
* RLC[28] P2A-P3B
Rrlc28 P2A nrlc28_1 25742.9300321
Lrlc28 nrlc28_1 nrlc28_2 7.49282838739e-12
Crlc28 nrlc28_2 P3B 0.001
* RLC[29] P2A-P4B
Rrlc29 P2A nrlc29_1 494.918076347
Lrlc29 nrlc29_1 nrlc29_2 3.94919318953e-06
Crlc29 nrlc29_2 P4B 8.92399967614e-11
* RLC[31] P2A-rlc1
Rrlc31 P2A nrlc31_1 1111.93483453
Lrlc31 nrlc31_1 nrlc31_2 6.94202586793e-05
Crlc31 nrlc31_2 rlc1 6.23856991132e-14
* RLC[32] P2A-rlc2
Rrlc32 P2A nrlc32_1 275051.913945
Lrlc32 nrlc32_1 nrlc32_2 1
Crlc32 nrlc32_2 rlc2 1.46868327041e-14
* RLC[34] P2A-rlc4
Rrlc34 P2A nrlc34_1 192182.858223
Lrlc34 nrlc34_1 nrlc34_2 1
Crlc34 nrlc34_2 rlc4 3.0083488393e-14
* RLC[36] P2A-rlc6
Rrlc36 P2A nrlc36_1 434.580112693
Lrlc36 nrlc36_1 nrlc36_2 2.2849071888e-05
Crlc36 nrlc36_2 rlc6 1.34426954062e-13
* RLC[38] P2A-rlc8
Rrlc38 P2A nrlc38_1 36.9535824473
Lrlc38 nrlc38_1 nrlc38_2 7.14446247083e-08
Crlc38 nrlc38_2 rlc8 5.81318247138e-14
* RLC[39] P2A-rlc9
Rrlc39 P2A nrlc39_1 97872.7389339
Lrlc39 nrlc39_1 nrlc39_2 1
Crlc39 nrlc39_2 rlc9 1.15993594375e-13
* RLC[40] P2A-rlc10
Rrlc40 P2A nrlc40_1 214830.914451
Lrlc40 nrlc40_1 nrlc40_2 1
Crlc40 nrlc40_2 rlc10 2.40748692089e-14
* RLC[42] P2A-rlc12
Rrlc42 P2A nrlc42_1 379314.135876
Lrlc42 nrlc42_1 nrlc42_2 1
Crlc42 nrlc42_2 rlc12 7.72252699143e-15
* RLC[43] P2A-rlc13
Rrlc43 P2A nrlc43_1 222.768583247
Lrlc43 nrlc43_1 nrlc43_2 1.0906036822e-05
Crlc43 nrlc43_2 rlc13 2.44183640627e-13
* RLC[44] P2A-rlc14
Rrlc44 P2A nrlc44_1 80474.743759
Lrlc44 nrlc44_1 nrlc44_2 1
Crlc44 nrlc44_2 rlc14 1.71568788871e-13
* RLC[46] P2A-GND
Rrlc46 P2A nrlc46_1 569737334237
Lrlc46 nrlc46_1 nrlc46_2 1.5075323977e-06
Crlc46 nrlc46_2 GND 1.71982551887e-05
* RLC[47] P3A-P4A
Rrlc47 P3A nrlc47_1 0.160054539319
Lrlc47 nrlc47_1 nrlc47_2 1.68257708761e-07
Crlc47 nrlc47_2 P4A 0.001
* RLC[48] P3A-P1B
Rrlc48 P3A nrlc48_1 981.803043962
Lrlc48 nrlc48_1 nrlc48_2 6.95987354835e-06
Crlc48 nrlc48_2 P1B 5.72882170717e-11
* RLC[49] P3A-P2B
Rrlc49 P3A nrlc49_1 2.09940673892
Lrlc49 nrlc49_1 nrlc49_2 1.02235007256e-07
Crlc49 nrlc49_2 P2B 2.57729391788e-11
* RLC[50] P3A-P3B
Rrlc50 P3A nrlc50_1 648.254041055
Lrlc50 nrlc50_1 nrlc50_2 4.1799336729e-06
Crlc50 nrlc50_2 P3B 4.64024267368e-11
* RLC[51] P3A-P4B
Rrlc51 P3A nrlc51_1 28548.3786173
Lrlc51 nrlc51_1 nrlc51_2 1.40673232257e-11
Crlc51 nrlc51_2 P4B 0.001
* RLC[55] P3A-rlc3
Rrlc55 P3A nrlc55_1 891.949338118
Lrlc55 nrlc55_1 nrlc55_2 4.46490908142e-05
Crlc55 nrlc55_2 rlc3 6.23576493077e-14
* RLC[57] P3A-rlc5
Rrlc57 P3A nrlc57_1 4.35142637376e+12
Lrlc57 nrlc57_1 nrlc57_2 0.999999847802
Crlc57 nrlc57_2 rlc5 9.48212517823e-06
* RLC[61] P3A-rlc9
Rrlc61 P3A nrlc61_1 301702.6792
Lrlc61 nrlc61_1 nrlc61_2 1
Crlc61 nrlc61_2 rlc9 1.22067248939e-14
* RLC[62] P3A-rlc10
Rrlc62 P3A nrlc62_1 79000.7129943
Lrlc62 nrlc62_1 nrlc62_2 1
Crlc62 nrlc62_2 rlc10 1.7803093339e-13
* RLC[63] P3A-rlc11
Rrlc63 P3A nrlc63_1 3.47963215299e+12
Lrlc63 nrlc63_1 nrlc63_2 0.999984867413
Crlc63 nrlc63_2 rlc11 4.02278610248e-08
* RLC[64] P3A-rlc12
Rrlc64 P3A nrlc64_1 170589.200613
Lrlc64 nrlc64_1 nrlc64_2 1
Crlc64 nrlc64_2 rlc12 3.81816262732e-14
* RLC[66] P3A-rlc14
Rrlc66 P3A nrlc66_1 123789.91015
Lrlc66 nrlc66_1 nrlc66_2 1
Crlc66 nrlc66_2 rlc14 7.25081784848e-14
* RLC[68] P3A-GND
Rrlc68 P3A nrlc68_1 2.3174112906e+12
Lrlc68 nrlc68_1 nrlc68_2 0.999989909835
Crlc68 nrlc68_2 GND 5.24675352847e-06
* RLC[69] P4A-P1B
Rrlc69 P4A nrlc69_1 2.07993141955
Lrlc69 nrlc69_1 nrlc69_2 1.01468427699e-07
Crlc69 nrlc69_2 P1B 2.60609588514e-11
* RLC[70] P4A-P2B
Rrlc70 P4A nrlc70_1 951.143764716
Lrlc70 nrlc70_1 nrlc70_2 6.75628840598e-06
Crlc70 nrlc70_2 P2B 6.01959672791e-11
* RLC[71] P4A-P3B
Rrlc71 P4A nrlc71_1 28558.4023932
Lrlc71 nrlc71_1 nrlc71_2 1.91078998758e-11
Crlc71 nrlc71_2 P3B 0.001
* RLC[72] P4A-P4B
Rrlc72 P4A nrlc72_1 345.621784888
Lrlc72 nrlc72_1 nrlc72_2 3.4679115228e-06
Crlc72 nrlc72_2 P4B 3.55511593929e-11
* RLC[74] P4A-rlc1
Rrlc74 P4A nrlc74_1 3.49512259558e+12
Lrlc74 nrlc74_1 nrlc74_2 0.0391527295632
Crlc74 nrlc74_2 rlc1 5.05017832965e-08
* RLC[76] P4A-rlc3
Rrlc76 P4A nrlc76_1 153657.09104
Lrlc76 nrlc76_1 nrlc76_2 1
Crlc76 nrlc76_2 rlc3 4.70600383113e-14
* RLC[79] P4A-rlc6
Rrlc79 P4A nrlc79_1 71750.2776308
Lrlc79 nrlc79_1 nrlc79_2 1
Crlc79 nrlc79_2 rlc6 2.15829258571e-13
* RLC[80] P4A-rlc7
Rrlc80 P4A nrlc80_1 51.1153210671
Lrlc80 nrlc80_1 nrlc80_2 1.79476253926e-08
Crlc80 nrlc80_2 rlc7 7.63242070007e-15
* RLC[82] P4A-rlc9
Rrlc82 P4A nrlc82_1 5285.34842084
Lrlc82 nrlc82_1 nrlc82_2 1.22697158919e-05
Crlc82 nrlc82_2 rlc9 8.43129816441e-14
* RLC[85] P4A-rlc12
Rrlc85 P4A nrlc85_1 339733.106642
Lrlc85 nrlc85_1 nrlc85_2 1
Crlc85 nrlc85_2 rlc12 9.62679557331e-15
* RLC[87] P4A-rlc14
Rrlc87 P4A nrlc87_1 1.43273420983e+12
Lrlc87 nrlc87_1 nrlc87_2 0.999986208248
Crlc87 nrlc87_2 rlc14 3.51949313114e-05
* RLC[92] P1B-P4B
Rrlc92 P1B nrlc92_1 21.5963618921
Lrlc92 nrlc92_1 nrlc92_2 6.52856512706e-15
Crlc92 nrlc92_2 P4B 7.08751432987e-10
* RLC[93] P1B-rlc0
Rrlc93 P1B nrlc93_1 271015.211388
Lrlc93 nrlc93_1 nrlc93_2 1
Crlc93 nrlc93_2 rlc0 1.51276042944e-14
* RLC[97] P1B-rlc4
Rrlc97 P1B nrlc97_1 0.0714725103511
Lrlc97 nrlc97_1 nrlc97_2 1.57734655524e-11
Crlc97 nrlc97_2 rlc4 3.43088799098e-12
* RLC[99] P1B-rlc6
Rrlc99 P1B nrlc99_1 425268.550535
Lrlc99 nrlc99_1 nrlc99_2 1
Crlc99 nrlc99_2 rlc6 6.14371352309e-15
* RLC[104] P1B-rlc11
Rrlc104 P1B nrlc104_1 339759.066232
Lrlc104 nrlc104_1 nrlc104_2 1
Crlc104 nrlc104_2 rlc11 9.62532454196e-15
* RLC[105] P1B-rlc12
Rrlc105 P1B nrlc105_1 23.2693184271
Lrlc105 nrlc105_1 nrlc105_2 7.05452060594e-08
Crlc105 nrlc105_2 rlc12 1.44763032281e-13
* RLC[107] P1B-rlc14
Rrlc107 P1B nrlc107_1 218696.436249
Lrlc107 nrlc107_1 nrlc107_2 1
Crlc107 nrlc107_2 rlc14 2.32313302357e-14
* RLC[109] P1B-GND
Rrlc109 P1B nrlc109_1 339762.394059
Lrlc109 nrlc109_1 nrlc109_2 1
Crlc109 nrlc109_2 GND 9.62513599106e-15
* RLC[111] P2B-P4B
Rrlc111 P2B nrlc111_1 0.01
Lrlc111 nrlc111_1 nrlc111_2 3.18973813565e-05
Crlc111 nrlc111_2 P4B 0.001
* RLC[119] P2B-rlc7
Rrlc119 P2B nrlc119_1 153923.08689
Lrlc119 nrlc119_1 nrlc119_2 1
Crlc119 nrlc119_2 rlc7 4.68975291116e-14
* RLC[123] P2B-rlc11
Rrlc123 P2B nrlc123_1 3934.70107405
Lrlc123 nrlc123_1 nrlc123_2 0.000238959781341
Crlc123 nrlc123_2 rlc11 1.71497903392e-14
* RLC[129] P3B-P4B
Rrlc129 P3B nrlc129_1 0.0239866534333
Lrlc129 nrlc129_1 nrlc129_2 6.07368312232e-06
Crlc129 nrlc129_2 P4B 0.001
* RLC[134] P3B-rlc4
Rrlc134 P3B nrlc134_1 97874.6051646
Lrlc134 nrlc134_1 nrlc134_2 1
Crlc134 nrlc134_2 rlc4 1.15989170985e-13
* RLC[143] P3B-rlc13
Rrlc143 P3B nrlc143_1 339762.235978
Lrlc143 nrlc143_1 nrlc143_2 1
Crlc143 nrlc143_2 rlc13 9.62514494759e-15
* RLC[144] P3B-rlc14
Rrlc144 P3B nrlc144_1 3.09528398099e+12
Lrlc144 nrlc144_1 nrlc144_2 0.99998878796
Crlc144 nrlc144_2 rlc14 2.89145369597e-05
* RLC[146] P3B-GND
Rrlc146 P3B nrlc146_1 2.73887566412e+12
Lrlc146 nrlc146_1 nrlc146_2 0.99998377948
Crlc146 nrlc146_2 GND 8.27019856955e-05
* RLC[147] P4B-rlc0
Rrlc147 P4B nrlc147_1 192182.219619
Lrlc147 nrlc147_1 nrlc147_2 1
Crlc147 nrlc147_2 rlc0 3.00836883229e-14
* RLC[153] P4B-rlc6
Rrlc153 P4B nrlc153_1 136363.379475
Lrlc153 nrlc153_1 nrlc153_2 1
Crlc153 nrlc153_2 rlc6 5.97533115519e-14
* RLC[155] P4B-rlc8
Rrlc155 P4B nrlc155_1 245187.70248
Lrlc155 nrlc155_1 nrlc155_2 1
Crlc155 nrlc155_2 rlc8 1.84824747825e-14
* RLC[157] P4B-rlc10
Rrlc157 P4B nrlc157_1 86708.8098476
Lrlc157 nrlc157_1 nrlc157_2 1
Crlc157 nrlc157_2 rlc10 1.47785232835e-13
* RLC[163] P4B-GND
Rrlc163 P4B nrlc163_1 271005.506766
Lrlc163 nrlc163_1 nrlc163_2 1
Crlc163 nrlc163_2 GND 1.51286877433e-14
* RLC[165] rlc0-rlc2
Rrlc165 rlc0 nrlc165_1 1.37096624504
Lrlc165 nrlc165_1 nrlc165_2 0.742723439048
Crlc165 nrlc165_2 rlc2 0.000439067302461
* RLC[167] rlc0-rlc4
Rrlc167 rlc0 nrlc167_1 2.10373973922
Lrlc167 nrlc167_1 nrlc167_2 0.000820651413797
Crlc167 nrlc167_2 rlc4 2.06030820019e-07
* RLC[169] rlc0-rlc6
Rrlc169 rlc0 nrlc169_1 0.0246161637847
Lrlc169 nrlc169_1 nrlc169_2 1.84386130168e-07
Crlc169 nrlc169_2 rlc6 3.38099862747e-07
* RLC[171] rlc0-rlc8
Rrlc171 rlc0 nrlc171_1 24440.3503422
Lrlc171 nrlc171_1 nrlc171_2 1
Crlc171 nrlc171_2 rlc8 1.86012717058e-12
* RLC[172] rlc0-rlc9
Rrlc172 rlc0 nrlc172_1 1.13373525761
Lrlc172 nrlc172_1 nrlc172_2 0.000287671216196
Crlc172 nrlc172_2 rlc9 2.48674122647e-07
* RLC[173] rlc0-rlc10
Rrlc173 rlc0 nrlc173_1 0.015507046837
Lrlc173 nrlc173_1 nrlc173_2 0.000106943103239
Crlc173 nrlc173_2 rlc10 0.00049414234909
* RLC[176] rlc0-rlc13
Rrlc176 rlc0 nrlc176_1 3.88807588535
Lrlc176 nrlc176_1 nrlc176_2 1.74074066237e-08
Crlc176 nrlc176_2 rlc13 1.27944640828e-12
* RLC[178] rlc0-rlc15
Rrlc178 rlc0 nrlc178_1 305576.881035
Lrlc178 nrlc178_1 nrlc178_2 1
Crlc178 nrlc178_2 rlc15 1.18991654438e-14
* RLC[179] rlc0-GND
Rrlc179 rlc0 nrlc179_1 1.49625860057
Lrlc179 nrlc179_1 nrlc179_2 0.108573896463
Crlc179 nrlc179_2 GND 5.38852118895e-05
* RLC[180] rlc1-rlc2
Rrlc180 rlc1 nrlc180_1 23991.4944295
Lrlc180 nrlc180_1 nrlc180_2 1
Crlc180 nrlc180_2 rlc2 1.93038035208e-12
* RLC[183] rlc1-rlc5
Rrlc183 rlc1 nrlc183_1 2.6266956514
Lrlc183 nrlc183_1 nrlc183_2 0.0449428302965
Crlc183 nrlc183_2 rlc5 7.23766369317e-06
* RLC[184] rlc1-rlc6
Rrlc184 rlc1 nrlc184_1 469.979894476
Lrlc184 nrlc184_1 nrlc184_2 1.53632594132e-05
Crlc184 nrlc184_2 rlc6 7.72827016132e-14
* RLC[185] rlc1-rlc7
Rrlc185 rlc1 nrlc185_1 46444.1128338
Lrlc185 nrlc185_1 nrlc185_2 0.63432900818
Crlc185 nrlc185_2 rlc7 3.26746331231e-13
* RLC[186] rlc1-rlc8
Rrlc186 rlc1 nrlc186_1 20232.2566377
Lrlc186 nrlc186_1 nrlc186_2 1
Crlc186 nrlc186_2 rlc8 2.71436870882e-12
* RLC[188] rlc1-rlc10
Rrlc188 rlc1 nrlc188_1 3.39683306561
Lrlc188 nrlc188_1 nrlc188_2 0.000103327897435
Crlc188 nrlc188_2 rlc10 9.95008232592e-09
* RLC[189] rlc1-rlc11
Rrlc189 rlc1 nrlc189_1 1.08503526155
Lrlc189 nrlc189_1 nrlc189_2 2.72184995708e-07
Crlc189 nrlc189_2 rlc11 2.56882173497e-10
* RLC[191] rlc1-rlc13
Rrlc191 rlc1 nrlc191_1 22.0584442686
Lrlc191 nrlc191_1 nrlc191_2 1.50771843938e-07
Crlc191 nrlc191_2 rlc13 3.44292829659e-13
* RLC[194] rlc1-GND
Rrlc194 rlc1 nrlc194_1 0.141206497535
Lrlc194 nrlc194_1 nrlc194_2 2.51370019035e-05
Crlc194 nrlc194_2 GND 1.40075314627e-06
* RLC[195] rlc2-rlc3
Rrlc195 rlc2 nrlc195_1 0.814051402098
Lrlc195 nrlc195_1 nrlc195_2 0.596411716732
Crlc195 nrlc195_2 rlc3 0.001
* RLC[196] rlc2-rlc4
Rrlc196 rlc2 nrlc196_1 2341.96527612
Lrlc196 nrlc196_1 nrlc196_2 0.000441722119279
Crlc196 nrlc196_2 rlc4 8.94840711682e-14
* RLC[197] rlc2-rlc5
Rrlc197 rlc2 nrlc197_1 8413.97170172
Lrlc197 nrlc197_1 nrlc197_2 1
Crlc197 nrlc197_2 rlc5 1.56947859295e-11
* RLC[198] rlc2-rlc6
Rrlc198 rlc2 nrlc198_1 0.951923620835
Lrlc198 nrlc198_1 nrlc198_2 0.761416154531
Crlc198 nrlc198_2 rlc6 0.000933631229944
* RLC[200] rlc2-rlc8
Rrlc200 rlc2 nrlc200_1 1.35099508209
Lrlc200 nrlc200_1 nrlc200_2 0.00023462211033
Crlc200 nrlc200_2 rlc8 1.42829820741e-07
* RLC[202] rlc2-rlc10
Rrlc202 rlc2 nrlc202_1 1.32861915006
Lrlc202 nrlc202_1 nrlc202_2 0.651937392566
Crlc202 nrlc202_2 rlc10 0.000410357491216
* RLC[204] rlc2-rlc12
Rrlc204 rlc2 nrlc204_1 18.5743668865
Lrlc204 nrlc204_1 nrlc204_2 0.68657328742
Crlc204 nrlc204_2 rlc12 2.21114057268e-06
* RLC[205] rlc2-rlc13
Rrlc205 rlc2 nrlc205_1 58.4324668994
Lrlc205 nrlc205_1 nrlc205_2 0.660352306218
Crlc205 nrlc205_2 rlc13 2.14894225728e-07
* RLC[206] rlc2-rlc14
Rrlc206 rlc2 nrlc206_1 1.79613615178
Lrlc206 nrlc206_1 nrlc206_2 1
Crlc206 nrlc206_2 rlc14 0.000344412560976
* RLC[212] rlc3-rlc7
Rrlc212 rlc3 nrlc212_1 0.159521027856
Lrlc212 nrlc212_1 nrlc212_2 0.00608892925573
Crlc212 nrlc212_2 rlc7 0.000265865839978
* RLC[213] rlc3-rlc8
Rrlc213 rlc3 nrlc213_1 7109.847861
Lrlc213 nrlc213_1 nrlc213_2 1
Crlc213 nrlc213_2 rlc8 2.19804649758e-11
* RLC[220] rlc3-rlc15
Rrlc220 rlc3 nrlc220_1 53640.1018237
Lrlc220 nrlc220_1 nrlc220_2 0.757439136094
Crlc220 nrlc220_2 rlc15 2.92500117102e-13
* RLC[221] rlc3-GND
Rrlc221 rlc3 nrlc221_1 0.0961850410859
Lrlc221 nrlc221_1 nrlc221_2 6.33254362026e-10
Crlc221 nrlc221_2 GND 7.60537461695e-11
* RLC[224] rlc4-rlc7
Rrlc224 rlc4 nrlc224_1 1.39165342501
Lrlc224 nrlc224_1 nrlc224_2 0.0121886047867
Crlc224 nrlc224_2 rlc7 6.99277090654e-06
* RLC[225] rlc4-rlc8
Rrlc225 rlc4 nrlc225_1 0.773132675412
Lrlc225 nrlc225_1 nrlc225_2 0.148670773683
Crlc225 nrlc225_2 rlc8 0.000276359905179
* RLC[226] rlc4-rlc9
Rrlc226 rlc4 nrlc226_1 0.152018419655
Lrlc226 nrlc226_1 nrlc226_2 8.5247156559e-07
Crlc226 nrlc226_2 rlc9 4.09868899482e-08
* RLC[235] rlc5-rlc7
Rrlc235 rlc5 nrlc235_1 245829.776442
Lrlc235 nrlc235_1 nrlc235_2 1
Crlc235 nrlc235_2 rlc7 1.8386053443e-14
* RLC[238] rlc5-rlc10
Rrlc238 rlc5 nrlc238_1 42646.757815
Lrlc238 nrlc238_1 nrlc238_2 0.914414198016
Crlc238 nrlc238_2 rlc10 5.58635346726e-13
* RLC[240] rlc5-rlc12
Rrlc240 rlc5 nrlc240_1 1.76797286711
Lrlc240 nrlc240_1 nrlc240_2 0.0262761373285
Crlc240 nrlc240_2 rlc12 9.34045047853e-06
* RLC[244] rlc5-GND
Rrlc244 rlc5 nrlc244_1 41950.5976436
Lrlc244 nrlc244_1 nrlc244_2 1
Crlc244 nrlc244_2 GND 6.31365992914e-13
* RLC[246] rlc6-rlc8
Rrlc246 rlc6 nrlc246_1 8151.5817535
Lrlc246 nrlc246_1 nrlc246_2 1
Crlc246 nrlc246_2 rlc8 1.67214414895e-11
* RLC[247] rlc6-rlc9
Rrlc247 rlc6 nrlc247_1 81.7836292826
Lrlc247 nrlc247_1 nrlc247_2 3.72423447403e-08
Crlc247 nrlc247_2 rlc9 3.9377156295e-14
* RLC[248] rlc6-rlc10
Rrlc248 rlc6 nrlc248_1 65.377782827
Lrlc248 nrlc248_1 nrlc248_2 0.000801895065814
Crlc248 nrlc248_2 rlc10 2.0845612263e-10
* RLC[251] rlc6-rlc13
Rrlc251 rlc6 nrlc251_1 569.976158794
Lrlc251 nrlc251_1 nrlc251_2 0.0109213642457
Crlc251 nrlc251_2 rlc13 3.7352614178e-11
* RLC[253] rlc6-rlc15
Rrlc253 rlc6 nrlc253_1 4.4934236305
Lrlc253 nrlc253_1 nrlc253_2 0.0795549970371
Crlc253 nrlc253_2 rlc15 1.32829535365e-05
* RLC[255] rlc7-rlc8
Rrlc255 rlc7 nrlc255_1 87081.6084506
Lrlc255 nrlc255_1 nrlc255_2 1
Crlc255 nrlc255_2 rlc8 1.46522596565e-13
* RLC[256] rlc7-rlc9
Rrlc256 rlc7 nrlc256_1 0.181079015829
Lrlc256 nrlc256_1 nrlc256_2 0.0295106489762
Crlc256 nrlc256_2 rlc9 0.001
* RLC[257] rlc7-rlc10
Rrlc257 rlc7 nrlc257_1 46.009583361
Lrlc257 nrlc257_1 nrlc257_2 0.0583560134868
Crlc257 nrlc257_2 rlc10 3.06299653473e-08
* RLC[259] rlc7-rlc12
Rrlc259 rlc7 nrlc259_1 14878.8477732
Lrlc259 nrlc259_1 nrlc259_2 1
Crlc259 nrlc259_2 rlc12 5.01901957587e-12
* RLC[260] rlc7-rlc13
Rrlc260 rlc7 nrlc260_1 0.409312113591
Lrlc260 nrlc260_1 nrlc260_2 0.0272053441826
Crlc260 nrlc260_2 rlc13 0.000180427411956
* RLC[261] rlc7-rlc14
Rrlc261 rlc7 nrlc261_1 1.27662278776
Lrlc261 nrlc261_1 nrlc261_2 0.067360793656
Crlc261 nrlc261_2 rlc14 4.59239781185e-05
* RLC[262] rlc7-rlc15
Rrlc262 rlc7 nrlc262_1 3.03053716623
Lrlc262 nrlc262_1 nrlc262_2 0.195467300763
Crlc262 nrlc262_2 rlc15 2.36478889496e-05
* RLC[263] rlc7-GND
Rrlc263 rlc7 nrlc263_1 0.188511971241
Lrlc263 nrlc263_1 nrlc263_2 0.0319830869711
Crlc263 nrlc263_2 GND 0.001
* RLC[266] rlc8-rlc11
Rrlc266 rlc8 nrlc266_1 403.149671554
Lrlc266 nrlc266_1 nrlc266_2 0.788310497778
Crlc266 nrlc266_2 rlc11 5.38917367834e-09
* RLC[267] rlc8-rlc12
Rrlc267 rlc8 nrlc267_1 39.9215331429
Lrlc267 nrlc267_1 nrlc267_2 0.648155082474
Crlc267 nrlc267_2 rlc12 4.51878832853e-07
* RLC[268] rlc8-rlc13
Rrlc268 rlc8 nrlc268_1 27502.1368972
Lrlc268 nrlc268_1 nrlc268_2 1
Crlc268 nrlc268_2 rlc13 1.4690095242e-12
* RLC[270] rlc8-rlc15
Rrlc270 rlc8 nrlc270_1 5.12790665448
Lrlc270 nrlc270_1 nrlc270_2 0.131147854741
Crlc270 nrlc270_2 rlc15 5.5416419175e-06
* RLC[271] rlc8-GND
Rrlc271 rlc8 nrlc271_1 20233.1931543
Lrlc271 nrlc271_1 nrlc271_2 1
Crlc271 nrlc271_2 GND 2.71411743928e-12
* RLC[274] rlc9-rlc12
Rrlc274 rlc9 nrlc274_1 12.9685869286
Lrlc274 nrlc274_1 nrlc274_2 1.93954779105e-05
Crlc274 nrlc274_2 rlc12 1.28136442061e-10
* RLC[277] rlc9-rlc15
Rrlc277 rlc9 nrlc277_1 305532.126288
Lrlc277 nrlc277_1 nrlc277_2 1
Crlc277 nrlc277_2 rlc15 1.19026517099e-14
* RLC[278] rlc9-GND
Rrlc278 rlc9 nrlc278_1 0.0240431440933
Lrlc278 nrlc278_1 nrlc278_2 7.54701650286e-09
Crlc278 nrlc278_2 GND 1.45060867988e-08
* RLC[284] rlc10-GND
Rrlc284 rlc10 nrlc284_1 0.01
Lrlc284 nrlc284_1 nrlc284_2 3.87133278009e-09
Crlc284 nrlc284_2 GND 9.36164771824e-06
* RLC[291] rlc12-rlc14
Rrlc291 rlc12 nrlc291_1 7.18600206414
Lrlc291 nrlc291_1 nrlc291_2 0.0958605475263
Crlc291 nrlc291_2 rlc14 2.06263660391e-06
* RLC[296] rlc13-GND
Rrlc296 rlc13 nrlc296_1 0.01
Lrlc296 nrlc296_1 nrlc296_2 1.05690485288e-10
Crlc296 nrlc296_2 GND 1.02630813232e-08
* RLC[299] rlc15-GND
Rrlc299 rlc15 nrlc299_1 0.252710362905
Lrlc299 nrlc299_1 nrlc299_2 0.0509436757002
Crlc299 nrlc299_2 GND 0.000886342684976
* DC[0] P1A-P2A
Rdc0 P1A ndc0_1 0.705561708333
Ldc0 ndc0_1 P2A 2.74879072623e-07
* DC[3] P1A-P1B
Rdc3 P1A ndc3_1 40781.8487482
Ldc3 ndc3_1 P1B 0.00649063281671
* DC[5] P1A-P3B
Rdc5 P1A ndc5_1 41116.5721865
Ldc5 ndc5_1 P3B 0.00654390570648
* DC[6] P1A-P4B
Rdc6 P1A ndc6_1 40514.8700725
Ldc6 ndc6_1 P4B 0.00644814184077
* DC[8] P1A-dc1
Rdc8 P1A ndc8_1 409264930162
Ldc8 ndc8_1 dc1 1
* DC[10] P1A-dc3
Rdc10 P1A ndc10_1 400304592054
Ldc10 ndc10_1 dc3 1
* DC[14] P2A-P1B
Rdc14 P2A ndc14_1 40939.384718
Ldc14 ndc14_1 P1B 0.00651570544501
* DC[15] P2A-P2B
Rdc15 P2A ndc15_1 40663.9375516
Ldc15 ndc15_1 P2B 0.00647186666692
* DC[17] P2A-P4B
Rdc17 P2A ndc17_1 41022.0096943
Ldc17 ndc17_1 P4B 0.00652885561841
* DC[23] P3A-P4A
Rdc23 P3A ndc23_1 0.694716880821
Ldc23 ndc23_1 P4A 2.92037621481e-06
* DC[24] P3A-P1B
Rdc24 P3A ndc24_1 43960.9447266
Ldc24 ndc24_1 P1B 0.00699660165623
* DC[25] P3A-P2B
Rdc25 P3A ndc25_1 43163.8365853
Ldc25 ndc25_1 P2B 0.00686973795536
* DC[26] P3A-P3B
Rdc26 P3A ndc26_1 43580.6326471
Ldc26 ndc26_1 P3B 0.00693607310886
* DC[33] P4A-P1B
Rdc33 P4A ndc33_1 43701.5004938
Ldc33 ndc33_1 P1B 0.00695530982412
* DC[34] P4A-P2B
Rdc34 P4A ndc34_1 44924.8341248
Ldc34 ndc34_1 P2B 0.00715000941855
* DC[36] P4A-P4B
Rdc36 P4A ndc36_1 42718.2187569
Ldc36 ndc36_1 P4B 0.00679881567524
* DC[42] P1B-P2B
Rdc42 P1B ndc42_1 0.0146597006654
Ldc42 ndc42_1 P2B 1.01656382517e-07
* DC[43] P1B-P3B
Rdc43 P1B ndc43_1 0.01
Ldc43 ndc43_1 P3B 8.51598346968e-09
* DC[44] P1B-P4B
Rdc44 P1B ndc44_1 0.0101108558908
Ldc44 ndc44_1 P4B 1.11988303286e-06
* DC[45] P1B-dc0
Rdc45 P1B ndc45_1 0.01
Ldc45 ndc45_1 dc0 2.67936832142e-08
* DC[46] P1B-dc1
Rdc46 P1B ndc46_1 0.01
Ldc46 ndc46_1 dc1 2.68666090861e-08
* DC[47] P1B-dc2
Rdc47 P1B ndc47_1 0.01
Ldc47 ndc47_1 dc2 2.58727446126e-08
* DC[48] P1B-dc3
Rdc48 P1B ndc48_1 0.01
Ldc48 ndc48_1 dc3 2.68666085167e-08
* DC[50] P2B-P3B
Rdc50 P2B ndc50_1 0.01
Ldc50 ndc50_1 P3B 2.91656016294e-07
* DC[51] P2B-P4B
Rdc51 P2B ndc51_1 0.01
Ldc51 ndc51_1 P4B 3.42844742196e-09
* DC[52] P2B-dc0
Rdc52 P2B ndc52_1 0.01
Ldc52 ndc52_1 dc0 1.13938269226e-06
* DC[53] P2B-dc1
Rdc53 P2B ndc53_1 0.01
Ldc53 ndc53_1 dc1 1.20593640244e-06
* DC[55] P2B-dc3
Rdc55 P2B ndc55_1 0.01
Ldc55 ndc55_1 dc3 1.20593705584e-06
* DC[57] P3B-P4B
Rdc57 P3B ndc57_1 0.01
Ldc57 ndc57_1 P4B 4.03286453549e-08
* DC[58] P3B-dc0
Rdc58 P3B ndc58_1 0.01
Ldc58 ndc58_1 dc0 1.59154943092e-09
* DC[59] P3B-dc1
Rdc59 P3B ndc59_1 0.01
Ldc59 ndc59_1 dc1 1.59154943092e-09
* DC[60] P3B-dc2
Rdc60 P3B ndc60_1 0.01
Ldc60 ndc60_1 dc2 1.59154943092e-09
* DC[61] P3B-dc3
Rdc61 P3B ndc61_1 0.01
Ldc61 ndc61_1 dc3 1.59154943092e-09
* DC[63] P4B-dc0
Rdc63 P4B ndc63_1 0.01
Ldc63 ndc63_1 dc0 4.49908174623e-07
* DC[64] P4B-dc1
Rdc64 P4B ndc64_1 0.01
Ldc64 ndc64_1 dc1 4.44538132818e-07
* DC[65] P4B-dc2
Rdc65 P4B ndc65_1 0.01
Ldc65 ndc65_1 dc2 4.48624760759e-07
* DC[66] P4B-dc3
Rdc66 P4B ndc66_1 0.01
Ldc66 ndc66_1 dc3 4.44538169484e-07
* DC[69] dc0-dc2
Rdc69 dc0 ndc69_1 0.01
Ldc69 ndc69_1 dc2 1.59154943092e-09
* DC[77] dc3-GND
Rdc77 dc3 ndc77_1 4.01131327069e+12
Ldc77 ndc77_1 GND 1
* ---- leaks
Rleak_P1A P1A GND 1e+12
Rleak_P1B P1B GND 1e+12
Rleak_P2A P2A GND 1e+12
Rleak_P2B P2B GND 1e+12
Rleak_P3A P3A GND 1e+12
Rleak_P3B P3B GND 1e+12
Rleak_P4A P4A GND 1e+12
Rleak_P4B P4B GND 1e+12
Rleak_dc0 dc0 GND 1e+12
Rleak_dc1 dc1 GND 1e+12
Rleak_dc2 dc2 GND 1e+12
Rleak_dc3 dc3 GND 1e+12
Rleak_rlc0 rlc0 GND 1e+12
Rleak_rlc1 rlc1 GND 1e+12
Rleak_rlc10 rlc10 GND 1e+12
Rleak_rlc11 rlc11 GND 1e+12
Rleak_rlc12 rlc12 GND 1e+12
Rleak_rlc13 rlc13 GND 1e+12
Rleak_rlc14 rlc14 GND 1e+12
Rleak_rlc15 rlc15 GND 1e+12
Rleak_rlc2 rlc2 GND 1e+12
Rleak_rlc3 rlc3 GND 1e+12
Rleak_rlc4 rlc4 GND 1e+12
Rleak_rlc5 rlc5 GND 1e+12
Rleak_rlc6 rlc6 GND 1e+12
Rleak_rlc7 rlc7 GND 1e+12
Rleak_rlc8 rlc8 GND 1e+12
Rleak_rlc9 rlc9 GND 1e+12
.ends fitted
