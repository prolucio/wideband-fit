* fitted: 8-port fitted model, reference z0 = 50 Ohm
* every pin is a port against GND
.subckt fitted P1A P1B P2A P2B P3A P3B P4A P4B GND
* ---- branches
* RLC[0] P1A-P2A
Rrlc0 P1A nrlc0_1 0.675359532811
Lrlc0 nrlc0_1 nrlc0_2 2.68420145538e-07
Crlc0 nrlc0_2 P2A 3.60539029355e-06
* RLC[1] P1A-P3A
Rrlc1 P1A nrlc1_1 18638.8618273
Lrlc1 nrlc1_1 nrlc1_2 4.48017515313e-12
Crlc1 nrlc1_2 P3A 3.3639511347e-07
* RLC[2] P1A-P4A
Rrlc2 P1A nrlc2_1 20936.6081147
Lrlc2 nrlc2_1 nrlc2_2 5.8182364614e-05
Crlc2 nrlc2_2 P4A 4.72210558685e-07
* RLC[3] P1A-P1B
Rrlc3 P1A nrlc3_1 0.142736168169
Lrlc3 nrlc3_1 nrlc3_2 1.29748470946e-07
Crlc3 nrlc3_2 P1B 0.000257562320359
* RLC[4] P1A-P2B
Rrlc4 P1A nrlc4_1 2.27428693908
Lrlc4 nrlc4_1 nrlc4_2 4.11164215836e-16
Crlc4 nrlc4_2 P2B 0.00022679954106
* RLC[5] P1A-P3B
Rrlc5 P1A nrlc5_1 0.245674822127
Lrlc5 nrlc5_1 nrlc5_2 6.19672397157e-07
Crlc5 nrlc5_2 P3B 0.000205281893661
* RLC[6] P1A-P4B
Rrlc6 P1A nrlc6_1 0.119810839223
Lrlc6 nrlc6_1 nrlc6_2 6.9011737057e-07
Crlc6 nrlc6_2 P4B 8.47456760006e-05
* RLC[7] P1A-rlc0
Rrlc7 P1A nrlc7_1 847729.050253
Lrlc7 nrlc7_1 nrlc7_2 1
Crlc7 nrlc7_2 rlc0 1.54612057169e-15
* RLC[11] P1A-rlc4
Rrlc11 P1A nrlc11_1 117055.315607
Lrlc11 nrlc11_1 nrlc11_2 1
Crlc11 nrlc11_2 rlc4 8.10914768721e-14
* RLC[24] P2A-P3A
Rrlc24 P2A nrlc24_1 29838.4856142
Lrlc24 nrlc24_1 nrlc24_2 7.20169730892e-05
Crlc24 nrlc24_2 P3A 0.001
* RLC[25] P2A-P4A
Rrlc25 P2A nrlc25_1 18641.8016363
Lrlc25 nrlc25_1 nrlc25_2 4.39685563412e-12
Crlc25 nrlc25_2 P4A 3.36441065867e-07
* RLC[26] P2A-P1B
Rrlc26 P2A nrlc26_1 0.01
Lrlc26 nrlc26_1 nrlc26_2 2.87564404094e-07
Crlc26 nrlc26_2 P1B 0.000121038829877
* RLC[27] P2A-P2B
Rrlc27 P2A nrlc27_1 0.143017293958
Lrlc27 nrlc27_1 nrlc27_2 1.22031014707e-07
Crlc27 nrlc27_2 P2B 0.000251312050442
* RLC[28] P2A-P3B
Rrlc28 P2A nrlc28_1 5.66490544006
Lrlc28 nrlc28_1 nrlc28_2 1.22031621268e-15
Crlc28 nrlc28_2 P3B 0.000211551251025
* RLC[29] P2A-P4B
Rrlc29 P2A nrlc29_1 0.224166132156
Lrlc29 nrlc29_1 nrlc29_2 9.67998795952e-07
Crlc29 nrlc29_2 P4B 0.000211530659781
* RLC[30] P2A-rlc0
Rrlc30 P2A nrlc30_1 222249.613889
Lrlc30 nrlc30_1 nrlc30_2 1
Crlc30 nrlc30_2 rlc0 2.24944542128e-14
* RLC[31] P2A-rlc1
Rrlc31 P2A nrlc31_1 157050.723186
Lrlc31 nrlc31_1 nrlc31_2 1
Crlc31 nrlc31_2 rlc1 4.50482173164e-14
* RLC[35] P2A-rlc5
Rrlc35 P2A nrlc35_1 246923.613682
Lrlc35 nrlc35_1 nrlc35_2 1
Crlc35 nrlc35_2 rlc5 1.82235189295e-14
* RLC[38] P2A-rlc8
Rrlc38 P2A nrlc38_1 381864.3497
Lrlc38 nrlc38_1 nrlc38_2 1
Crlc38 nrlc38_2 rlc8 7.61972434262e-15
* RLC[39] P2A-rlc9
Rrlc39 P2A nrlc39_1 477729.584099
Lrlc39 nrlc39_1 nrlc39_2 1
Crlc39 nrlc39_2 rlc9 4.86847806575e-15
* RLC[47] P3A-P4A
Rrlc47 P3A nrlc47_1 0.160912742368
Lrlc47 nrlc47_1 nrlc47_2 1.71604469304e-07
Crlc47 nrlc47_2 P4A 0.001
* RLC[48] P3A-P1B
Rrlc48 P3A nrlc48_1 1345.51273027
Lrlc48 nrlc48_1 nrlc48_2 9.62724506248e-06
Crlc48 nrlc48_2 P1B 6.32630173108e-11
* RLC[49] P3A-P2B
Rrlc49 P3A nrlc49_1 0.01
Lrlc49 nrlc49_1 nrlc49_2 8.24166497871e-15
Crlc49 nrlc49_2 P2B 1.75203687985e-11
* RLC[50] P3A-P3B
Rrlc50 P3A nrlc50_1 612.634115711
Lrlc50 nrlc50_1 nrlc50_2 6.15659052224e-06
Crlc50 nrlc50_2 P3B 3.20821749787e-11
* RLC[51] P3A-P4B
Rrlc51 P3A nrlc51_1 11.4820425732
Lrlc51 nrlc51_1 nrlc51_2 1.89700777182e-15
Crlc51 nrlc51_2 P4B 2.22207308064e-11
* RLC[59] P3A-rlc7
Rrlc59 P3A nrlc59_1 274206.124858
Lrlc59 nrlc59_1 nrlc59_2 1
Crlc59 nrlc59_2 rlc7 1.47775755392e-14
* RLC[69] P4A-P1B
Rrlc69 P4A nrlc69_1 2.49584744017
Lrlc69 nrlc69_1 nrlc69_2 9.89390841806e-08
Crlc69 nrlc69_2 P1B 1.7647748496e-11
* RLC[70] P4A-P2B
Rrlc70 P4A nrlc70_1 1128.18810942
Lrlc70 nrlc70_1 nrlc70_2 8.7456951772e-06
Crlc70 nrlc70_2 P2B 5.53669935258e-11
* RLC[71] P4A-P3B
Rrlc71 P4A nrlc71_1 43.1615418279
Lrlc71 nrlc71_1 nrlc71_2 6.8358693209e-08
Crlc71 nrlc71_2 P3B 1.95120454688e-11
* RLC[72] P4A-P4B
Rrlc72 P4A nrlc72_1 412.123749091
Lrlc72 nrlc72_1 nrlc72_2 5.46021998192e-06
Crlc72 nrlc72_2 P4B 2.65519987533e-11
* RLC[78] P4A-rlc5
Rrlc78 P4A nrlc78_1 0.297837258992
Lrlc78 nrlc78_1 nrlc78_2 2.75749464625e-12
Crlc78 nrlc78_2 rlc5 3.45393464537e-14
* RLC[80] P4A-rlc7
Rrlc80 P4A nrlc80_1 19434.1530711
Lrlc80 nrlc80_1 nrlc80_2 0.000788432240891
Crlc80 nrlc80_2 rlc7 2.31947997649e-15
* RLC[84] P4A-rlc11
Rrlc84 P4A nrlc84_1 246713.099381
Lrlc84 nrlc84_1 nrlc84_2 1
Crlc84 nrlc84_2 rlc11 1.82546315707e-14
* RLC[86] P4A-rlc13
Rrlc86 P4A nrlc86_1 157101.961827
Lrlc86 nrlc86_1 nrlc86_2 1
Crlc86 nrlc86_2 rlc13 4.501883725e-14
* RLC[87] P4A-rlc14
Rrlc87 P4A nrlc87_1 340348.019407
Lrlc87 nrlc87_1 nrlc87_2 1
Crlc87 nrlc87_2 rlc14 9.59204119496e-15
* RLC[90] P1B-P2B
Rrlc90 P1B nrlc90_1 0.0779251213479
Lrlc90 nrlc90_1 nrlc90_2 1.59083715204e-05
Crlc90 nrlc90_2 P2B 0.001
* RLC[91] P1B-P3B
Rrlc91 P1B nrlc91_1 0.01
Lrlc91 nrlc91_1 nrlc91_2 1.10458087071e-08
Crlc91 nrlc91_2 P3B 0.001
* RLC[92] P1B-P4B
Rrlc92 P1B nrlc92_1 17.1581024809
Lrlc92 nrlc92_1 nrlc92_2 3.06942654761e-09
Crlc92 nrlc92_2 P4B 7.21132044705e-10
* RLC[94] P1B-rlc1
Rrlc94 P1B nrlc94_1 100355.72846
Lrlc94 nrlc94_1 nrlc94_2 1
Crlc94 nrlc94_2 rlc1 1.10324801596e-13
* RLC[100] P1B-rlc7
Rrlc100 P1B nrlc100_1 175.344288954
Lrlc100 nrlc100_1 nrlc100_2 5.75203079328e-07
Crlc100 nrlc100_2 rlc7 2.07871735705e-14
* RLC[109] P1B-GND
Rrlc109 P1B nrlc109_1 373646416804
Lrlc109 nrlc109_1 nrlc109_2 1
Crlc109 nrlc109_2 GND 0.000701107240687
* RLC[110] P2B-P3B
Rrlc110 P2B nrlc110_1 0.0240993664013
Lrlc110 nrlc110_1 nrlc110_2 0.000202905154905
Crlc110 nrlc110_2 P3B 0.001
* RLC[111] P2B-P4B
Rrlc111 P2B nrlc111_1 0.01
Lrlc111 nrlc111_1 nrlc111_2 1.22851739561e-08
Crlc111 nrlc111_2 P4B 0.001
* RLC[125] P2B-rlc13
Rrlc125 P2B nrlc125_1 141.335545
Lrlc125 nrlc125_1 nrlc125_2 5.5235392526e-07
Crlc125 nrlc125_2 rlc13 3.0723602625e-14
* RLC[129] P3B-P4B
Rrlc129 P3B nrlc129_1 0.111098167703
Lrlc129 nrlc129_1 nrlc129_2 1.7542432521e-07
Crlc129 nrlc129_2 P4B 0.001
* RLC[132] P3B-rlc2
Rrlc132 P3B nrlc132_1 246734.596499
Lrlc132 nrlc132_1 nrlc132_2 1
Crlc132 nrlc132_2 rlc2 1.82514507855e-14
* RLC[135] P3B-rlc5
Rrlc135 P3B nrlc135_1 305901.910396
Lrlc135 nrlc135_1 nrlc135_2 1
Crlc135 nrlc135_2 rlc5 1.18738924834e-14
* RLC[136] P3B-rlc6
Rrlc136 P3B nrlc136_1 222856.357241
Lrlc136 nrlc136_1 nrlc136_2 1
Crlc136 nrlc136_2 rlc6 2.23721352325e-14
* RLC[137] P3B-rlc7
Rrlc137 P3B nrlc137_1 274230.557655
Lrlc137 nrlc137_1 nrlc137_2 1
Crlc137 nrlc137_2 rlc7 1.47749424161e-14
* RLC[139] P3B-rlc9
Rrlc139 P3B nrlc139_1 340537.343009
Lrlc139 nrlc139_1 nrlc139_2 1
Crlc139 nrlc139_2 rlc9 9.58137866399e-15
* RLC[141] P3B-rlc11
Rrlc141 P3B nrlc141_1 0.688999588536
Lrlc141 nrlc141_1 nrlc141_2 2.15588382306e-09
Crlc141 nrlc141_2 rlc11 5.04597296332e-12
* RLC[150] P4B-rlc3
Rrlc150 P4B nrlc150_1 305929.770527
Lrlc150 nrlc150_1 nrlc150_2 1
Crlc150 nrlc150_2 rlc3 1.18717299405e-14
* RLC[152] P4B-rlc5
Rrlc152 P4B nrlc152_1 19657.9252739
Lrlc152 nrlc152_1 nrlc152_2 0.00221535140295
Crlc152 nrlc152_2 rlc5 6.36978473104e-15
* RLC[154] P4B-rlc7
Rrlc154 P4B nrlc154_1 3005657.32319
Lrlc154 nrlc154_1 nrlc154_2 1
Crlc154 nrlc154_2 rlc7 1.22992480603e-16
* RLC[155] P4B-rlc8
Rrlc155 P4B nrlc155_1 381862.352621
Lrlc155 nrlc155_1 nrlc155_2 1
Crlc155 nrlc155_2 rlc8 7.61980404271e-15
* RLC[156] P4B-rlc9
Rrlc156 P4B nrlc156_1 305914.288517
Lrlc156 nrlc156_1 nrlc156_2 1
Crlc156 nrlc156_2 rlc9 1.18729316031e-14
* RLC[158] P4B-rlc11
Rrlc158 P4B nrlc158_1 141666.407364
Lrlc158 nrlc158_1 nrlc158_2 1
Crlc158 nrlc158_2 rlc11 5.53635244708e-14
* RLC[161] P4B-rlc14
Rrlc161 P4B nrlc161_1 222271.8948
Lrlc161 nrlc161_1 nrlc161_2 1
Crlc161 nrlc161_2 rlc14 2.24899446746e-14
* RLC[164] rlc0-rlc1
Rrlc164 rlc0 nrlc164_1 0.314478237999
Lrlc164 nrlc164_1 nrlc164_2 0.000679916703148
Crlc164 nrlc164_2 rlc1 1.08084508218e-05
* RLC[165] rlc0-rlc2
Rrlc165 rlc0 nrlc165_1 0.60155933558
Lrlc165 nrlc165_1 nrlc165_2 0.230901968691
Crlc165 nrlc165_2 rlc2 0.000708970532048
* RLC[166] rlc0-rlc3
Rrlc166 rlc0 nrlc166_1 7.99212744566
Lrlc166 nrlc166_1 nrlc166_2 0.15816310382
Crlc166 nrlc166_2 rlc3 2.75129949345e-06
* RLC[167] rlc0-rlc4
Rrlc167 rlc0 nrlc167_1 1.19733395415
Lrlc167 nrlc167_1 nrlc167_2 1
Crlc167 nrlc167_2 rlc4 0.000775044954979
* RLC[168] rlc0-rlc5
Rrlc168 rlc0 nrlc168_1 1046.31460164
Lrlc168 nrlc168_1 nrlc168_2 0.933845129594
Crlc168 nrlc168_2 rlc5 9.47780516132e-10
* RLC[171] rlc0-rlc8
Rrlc171 rlc0 nrlc171_1 3.87535528515
Lrlc171 nrlc171_1 nrlc171_2 1
Crlc171 nrlc171_2 rlc8 7.39834266887e-05
* RLC[172] rlc0-rlc9
Rrlc172 rlc0 nrlc172_1 0.239073689335
Lrlc172 nrlc172_1 nrlc172_2 0.0212580494073
Crlc172 nrlc172_2 rlc9 0.000413254256594
* RLC[173] rlc0-rlc10
Rrlc173 rlc0 nrlc173_1 0.460218046774
Lrlc173 nrlc173_1 nrlc173_2 0.190607245884
Crlc173 nrlc173_2 rlc10 0.000999930019967
* RLC[174] rlc0-rlc11
Rrlc174 rlc0 nrlc174_1 209.042507941
Lrlc174 nrlc174_1 nrlc174_2 3.17237480676e-08
Crlc174 nrlc174_2 rlc11 8.55731960893e-12
* RLC[175] rlc0-rlc12
Rrlc175 rlc0 nrlc175_1 156.654311698
Lrlc175 nrlc175_1 nrlc175_2 1
Crlc175 nrlc175_2 rlc12 4.52764935112e-08
* RLC[176] rlc0-rlc13
Rrlc176 rlc0 nrlc176_1 46.3777641772
Lrlc176 nrlc176_1 nrlc176_2 1
Crlc176 nrlc176_2 rlc13 5.16580341088e-07
* RLC[177] rlc0-rlc14
Rrlc177 rlc0 nrlc177_1 1996.54042909
Lrlc177 nrlc177_1 nrlc177_2 0.243912571886
Crlc177 nrlc177_2 rlc14 6.7988499794e-11
* RLC[178] rlc0-rlc15
Rrlc178 rlc0 nrlc178_1 86.5586476338
Lrlc178 nrlc178_1 nrlc178_2 0.0185845561948
Crlc178 nrlc178_2 rlc15 2.75606058348e-09
* RLC[179] rlc0-GND
Rrlc179 rlc0 nrlc179_1 0.189181106782
Lrlc179 nrlc179_1 nrlc179_2 3.09737196257e-09
Crlc179 nrlc179_2 GND 1.31525175158e-10
* RLC[180] rlc1-rlc2
Rrlc180 rlc1 nrlc180_1 1.14169677885
Lrlc180 nrlc180_1 nrlc180_2 0.99996154876
Crlc180 nrlc180_2 rlc2 0.00085239175372
* RLC[181] rlc1-rlc3
Rrlc181 rlc1 nrlc181_1 1.35681496333
Lrlc181 nrlc181_1 nrlc181_2 0.399040183323
Crlc181 nrlc181_2 rlc3 0.000240842359323
* RLC[182] rlc1-rlc4
Rrlc182 rlc1 nrlc182_1 1.12867130331
Lrlc182 nrlc182_1 nrlc182_2 1
Crlc182 nrlc182_2 rlc4 0.00087221293746
* RLC[185] rlc1-rlc7
Rrlc185 rlc1 nrlc185_1 91.5796128197
Lrlc185 nrlc185_1 nrlc185_2 0.648657701684
Crlc185 nrlc185_2 rlc7 8.59360649636e-08
* RLC[187] rlc1-rlc9
Rrlc187 rlc1 nrlc187_1 193.058681752
Lrlc187 nrlc187_1 nrlc187_2 0.448510907928
Crlc187 nrlc187_2 rlc9 1.33706286615e-08
* RLC[188] rlc1-rlc10
Rrlc188 rlc1 nrlc188_1 10.9342062751
Lrlc188 nrlc188_1 nrlc188_2 0.309144795877
Crlc188 nrlc188_2 rlc10 2.87306138614e-06
* RLC[189] rlc1-rlc11
Rrlc189 rlc1 nrlc189_1 50.1748013953
Lrlc189 nrlc189_1 nrlc189_2 1
Crlc189 nrlc189_2 rlc11 4.41353084733e-07
* RLC[193] rlc1-rlc15
Rrlc193 rlc1 nrlc193_1 774.363803895
Lrlc193 nrlc193_1 nrlc193_2 1
Crlc193 nrlc193_2 rlc15 1.8529657907e-09
* RLC[194] rlc1-GND
Rrlc194 rlc1 nrlc194_1 0.528265304535
Lrlc194 nrlc194_1 nrlc194_2 0.000167304036847
Crlc194 nrlc194_2 GND 1.05704928386e-06
* RLC[195] rlc2-rlc3
Rrlc195 rlc2 nrlc195_1 520.964152045
Lrlc195 nrlc195_1 nrlc195_2 0.128448215347
Crlc195 nrlc195_2 rlc3 5.25859694502e-10
* RLC[196] rlc2-rlc4
Rrlc196 rlc2 nrlc196_1 1851.36522737
Lrlc196 nrlc196_1 nrlc196_2 1
Crlc196 nrlc196_2 rlc4 3.24170346782e-10
* RLC[198] rlc2-rlc6
Rrlc198 rlc2 nrlc198_1 37.3016669387
Lrlc198 nrlc198_1 nrlc198_2 1
Crlc198 nrlc198_2 rlc6 7.98547970988e-07
* RLC[199] rlc2-rlc7
Rrlc199 rlc2 nrlc199_1 10.7196153734
Lrlc199 nrlc199_1 nrlc199_2 0.311208525267
Crlc199 nrlc199_2 rlc7 3.00919665499e-06
* RLC[201] rlc2-rlc9
Rrlc201 rlc2 nrlc201_1 138.379389846
Lrlc201 nrlc201_1 nrlc201_2 0.0292487648889
Crlc201 nrlc201_2 rlc9 1.697157702e-09
* RLC[202] rlc2-rlc10
Rrlc202 rlc2 nrlc202_1 1.69782499336
Lrlc202 nrlc202_1 nrlc202_2 0.00194354449731
Crlc202 nrlc202_2 rlc10 7.49145428825e-07
* RLC[203] rlc2-rlc11
Rrlc203 rlc2 nrlc203_1 0.12200428512
Lrlc203 nrlc203_1 nrlc203_2 3.23027440774e-06
Crlc203 nrlc203_2 rlc11 2.41127497073e-07
* RLC[204] rlc2-rlc12
Rrlc204 rlc2 nrlc204_1 1931.33068425
Lrlc204 nrlc204_1 nrlc204_2 1
Crlc204 nrlc204_2 rlc12 2.97881964738e-10
* RLC[206] rlc2-rlc14
Rrlc206 rlc2 nrlc206_1 0.535605374872
Lrlc206 nrlc206_1 nrlc206_2 3.77151866594e-08
Crlc206 nrlc206_2 rlc14 1.4607769214e-10
* RLC[207] rlc2-rlc15
Rrlc207 rlc2 nrlc207_1 737.537004171
Lrlc207 nrlc207_1 nrlc207_2 0.75822629771
Crlc207 nrlc207_2 rlc15 1.54877633417e-09
* RLC[209] rlc3-rlc4
Rrlc209 rlc3 nrlc209_1 1992.17821214
Lrlc209 nrlc209_1 nrlc209_2 0.000122897711346
Crlc209 nrlc209_2 rlc4 3.4406849977e-14
* RLC[210] rlc3-rlc5
Rrlc210 rlc3 nrlc210_1 50.8428870469
Lrlc210 nrlc210_1 nrlc210_2 0.933815222196
Crlc210 nrlc210_2 rlc5 4.01382129577e-07
* RLC[213] rlc3-rlc8
Rrlc213 rlc3 nrlc213_1 48.2301068408
Lrlc213 nrlc213_1 nrlc213_2 1
Crlc213 nrlc213_2 rlc8 4.77662384804e-07
* RLC[214] rlc3-rlc9
Rrlc214 rlc3 nrlc214_1 0.734711592676
Lrlc214 nrlc214_1 nrlc214_2 0.00603318801825
Crlc214 nrlc214_2 rlc9 1.24185407168e-05
* RLC[216] rlc3-rlc11
Rrlc216 rlc3 nrlc216_1 46.7329041777
Lrlc216 nrlc216_1 nrlc216_2 0.891908710735
Crlc216 nrlc216_2 rlc11 4.53766420849e-07
* RLC[217] rlc3-rlc12
Rrlc217 rlc3 nrlc217_1 2707.51053828
Lrlc217 nrlc217_1 nrlc217_2 1
Crlc217 nrlc217_2 rlc12 1.51571371096e-10
* RLC[218] rlc3-rlc13
Rrlc218 rlc3 nrlc218_1 1.30389498605
Lrlc218 nrlc218_1 nrlc218_2 1
Crlc218 nrlc218_2 rlc13 0.000653540129661
* RLC[219] rlc3-rlc14
Rrlc219 rlc3 nrlc219_1 13.7138314903
Lrlc219 nrlc219_1 nrlc219_2 0.35713759057
Crlc219 nrlc219_2 rlc14 2.10996590421e-06
* RLC[220] rlc3-rlc15
Rrlc220 rlc3 nrlc220_1 21.2135219416
Lrlc220 nrlc220_1 nrlc220_2 0.000239122860921
Crlc220 nrlc220_2 rlc15 5.90409087544e-10
* RLC[221] rlc3-GND
Rrlc221 rlc3 nrlc221_1 10.4688637391
Lrlc221 nrlc221_1 nrlc221_2 0.00540722682204
Crlc221 nrlc221_2 GND 5.48192366807e-08
* RLC[223] rlc4-rlc6
Rrlc223 rlc4 nrlc223_1 235.430220455
Lrlc223 nrlc223_1 nrlc223_2 1
Crlc223 nrlc223_2 rlc6 2.00462467582e-08
* RLC[225] rlc4-rlc8
Rrlc225 rlc4 nrlc225_1 2.57641796472
Lrlc225 nrlc225_1 nrlc225_2 1
Crlc225 nrlc225_2 rlc8 0.000167388205353
* RLC[226] rlc4-rlc9
Rrlc226 rlc4 nrlc226_1 2928.45554562
Lrlc226 nrlc226_1 nrlc226_2 1
Crlc226 nrlc226_2 rlc9 1.29562768377e-10
* RLC[228] rlc4-rlc11
Rrlc228 rlc4 nrlc228_1 83.6543746517
Lrlc228 nrlc228_1 nrlc228_2 1
Crlc228 nrlc228_2 rlc11 1.58774288947e-07
* RLC[229] rlc4-rlc12
Rrlc229 rlc4 nrlc229_1 1290.15251714
Lrlc229 nrlc229_1 nrlc229_2 1
Crlc229 nrlc229_2 rlc12 6.67537061237e-10
* RLC[231] rlc4-rlc14
Rrlc231 rlc4 nrlc231_1 196.911650939
Lrlc231 nrlc231_1 nrlc231_2 1
Crlc231 nrlc231_2 rlc14 2.86559403037e-08
* RLC[233] rlc4-GND
Rrlc233 rlc4 nrlc233_1 2.09204338224
Lrlc233 nrlc233_1 nrlc233_2 1
Crlc233 nrlc233_2 GND 0.000253872768029
* RLC[234] rlc5-rlc6
Rrlc234 rlc5 nrlc234_1 48.8042088132
Lrlc234 nrlc234_1 nrlc234_2 1
Crlc234 nrlc234_2 rlc6 4.66490643369e-07
* RLC[235] rlc5-rlc7
Rrlc235 rlc5 nrlc235_1 33.3383949195
Lrlc235 nrlc235_1 nrlc235_2 0.507094484347
Crlc235 nrlc235_2 rlc7 5.06940517271e-07
* RLC[236] rlc5-rlc8
Rrlc236 rlc5 nrlc236_1 30.0453805116
Lrlc236 nrlc236_1 nrlc236_2 0.000117022806302
Crlc236 nrlc236_2 rlc8 1.44036507427e-10
* RLC[238] rlc5-rlc10
Rrlc238 rlc5 nrlc238_1 34.9557223877
Lrlc238 nrlc238_1 nrlc238_2 0.582887123807
Crlc238 nrlc238_2 rlc10 5.30036025894e-07
* RLC[239] rlc5-rlc11
Rrlc239 rlc5 nrlc239_1 100.521908771
Lrlc239 nrlc239_1 nrlc239_2 0.00167012668983
Crlc239 nrlc239_2 rlc11 1.83647683113e-10
* RLC[243] rlc5-rlc15
Rrlc243 rlc5 nrlc243_1 950.732625519
Lrlc243 nrlc243_1 nrlc243_2 0.984001727882
Crlc243 nrlc243_2 rlc15 1.209585457e-09
* RLC[246] rlc6-rlc8
Rrlc246 rlc6 nrlc246_1 31.8944319187
Lrlc246 nrlc246_1 nrlc246_2 1
Crlc246 nrlc246_2 rlc8 1.09226432242e-06
* RLC[247] rlc6-rlc9
Rrlc247 rlc6 nrlc247_1 9.9169601382
Lrlc247 nrlc247_1 nrlc247_2 1
Crlc247 nrlc247_2 rlc9 1.12979683931e-05
* RLC[248] rlc6-rlc10
Rrlc248 rlc6 nrlc248_1 14.2384148296
Lrlc248 nrlc248_1 nrlc248_2 1
Crlc248 nrlc248_2 rlc10 5.48067698836e-06
* RLC[249] rlc6-rlc11
Rrlc249 rlc6 nrlc249_1 3777.46605701
Lrlc249 nrlc249_1 nrlc249_2 1
Crlc249 nrlc249_2 rlc11 7.78675211213e-11
* RLC[252] rlc6-rlc14
Rrlc252 rlc6 nrlc252_1 1860.57871925
Lrlc252 nrlc252_1 nrlc252_2 1
Crlc252 nrlc252_2 rlc14 3.2096774564e-10
* RLC[253] rlc6-rlc15
Rrlc253 rlc6 nrlc253_1 911.50530296
Lrlc253 nrlc253_1 nrlc253_2 0.000137520892333
Crlc253 nrlc253_2 rlc15 1.83911028434e-13
* RLC[254] rlc6-GND
Rrlc254 rlc6 nrlc254_1 67.7672800443
Lrlc254 nrlc254_1 nrlc254_2 1
Crlc254 nrlc254_2 GND 2.41945406356e-07
* RLC[255] rlc7-rlc8
Rrlc255 rlc7 nrlc255_1 65.165173353
Lrlc255 nrlc255_1 nrlc255_2 1
Crlc255 nrlc255_2 rlc8 2.61653398964e-07
* RLC[256] rlc7-rlc9
Rrlc256 rlc7 nrlc256_1 1.04076864681
Lrlc256 nrlc256_1 nrlc256_2 0.140185461108
Crlc256 nrlc256_2 rlc9 0.000143797741099
* RLC[257] rlc7-rlc10
Rrlc257 rlc7 nrlc257_1 462.546592426
Lrlc257 nrlc257_1 nrlc257_2 0.000759830801902
Crlc257 nrlc257_2 rlc10 3.94605754075e-12
* RLC[258] rlc7-rlc11
Rrlc258 rlc7 nrlc258_1 25.7744849101
Lrlc258 nrlc258_1 nrlc258_2 0.357014479678
Crlc258 nrlc258_2 rlc11 5.97122355924e-07
* RLC[260] rlc7-rlc13
Rrlc260 rlc7 nrlc260_1 171.067337409
Lrlc260 nrlc260_1 nrlc260_2 1
Crlc260 nrlc260_2 rlc13 3.79684876609e-08
* RLC[262] rlc7-rlc15
Rrlc262 rlc7 nrlc262_1 645.468581512
Lrlc262 nrlc262_1 nrlc262_2 1
Crlc262 nrlc262_2 rlc15 2.66690334014e-09
* RLC[263] rlc7-GND
Rrlc263 rlc7 nrlc263_1 84.1836808036
Lrlc263 nrlc263_1 nrlc263_2 0.499959654703
Crlc263 nrlc263_2 GND 7.83856616611e-08
* RLC[264] rlc8-rlc9
Rrlc264 rlc8 nrlc264_1 614.534505468
Lrlc264 nrlc264_1 nrlc264_2 1
Crlc264 nrlc264_2 rlc9 2.94215090604e-09
* RLC[268] rlc8-rlc13
Rrlc268 rlc8 nrlc268_1 0.149885306426
Lrlc268 nrlc268_1 nrlc268_2 8.21754412718e-07
Crlc268 nrlc268_2 rlc13 4.0642593655e-08
* RLC[269] rlc8-rlc14
Rrlc269 rlc8 nrlc269_1 6142.62580907
Lrlc269 nrlc269_1 nrlc269_2 3.93386038267e-08
Crlc269 nrlc269_2 rlc14 1.12245559589e-13
* RLC[270] rlc8-rlc15
Rrlc270 rlc8 nrlc270_1 371.865290188
Lrlc270 nrlc270_1 nrlc270_2 1
Crlc270 nrlc270_2 rlc15 8.03500597283e-09
* RLC[272] rlc9-rlc10
Rrlc272 rlc9 nrlc272_1 64.5145563331
Lrlc272 nrlc272_1 nrlc272_2 7.54365371474e-05
Crlc272 nrlc272_2 rlc10 2.0138346306e-11
* RLC[273] rlc9-rlc11
Rrlc273 rlc9 nrlc273_1 1.29853836026
Lrlc273 nrlc273_1 nrlc273_2 0.00463725147861
Crlc273 nrlc273_2 rlc11 3.05568492432e-06
* RLC[274] rlc9-rlc12
Rrlc274 rlc9 nrlc274_1 1.05409255339
Lrlc274 nrlc274_1 nrlc274_2 1
Crlc274 nrlc274_2 rlc12 0.001
* RLC[275] rlc9-rlc13
Rrlc275 rlc9 nrlc275_1 491.35125533
Lrlc275 nrlc275_1 nrlc275_2 1
Crlc275 nrlc275_2 rlc13 4.60228332018e-09
* RLC[276] rlc9-rlc14
Rrlc276 rlc9 nrlc276_1 1878.45094976
Lrlc276 nrlc276_1 nrlc276_2 1
Crlc276 nrlc276_2 rlc14 3.1488920476e-10
* RLC[277] rlc9-rlc15
Rrlc277 rlc9 nrlc277_1 121.062289039
Lrlc277 nrlc277_1 nrlc277_2 0.000350333462607
Crlc277 nrlc277_2 rlc15 2.65595889623e-11
* RLC[278] rlc9-GND
Rrlc278 rlc9 nrlc278_1 1.29334212246
Lrlc278 nrlc278_1 nrlc278_2 0.43135954709
Crlc278 nrlc278_2 GND 0.000286529974196
* RLC[279] rlc10-rlc11
Rrlc279 rlc10 nrlc279_1 3257.72762489
Lrlc279 nrlc279_1 nrlc279_2 0.502662676353
Crlc279 nrlc279_2 rlc11 5.262651224e-11
* RLC[280] rlc10-rlc12
Rrlc280 rlc10 nrlc280_1 49.7660872494
Lrlc280 nrlc280_1 nrlc280_2 1
Crlc280 nrlc280_2 rlc12 4.48632257864e-07
* RLC[281] rlc10-rlc13
Rrlc281 rlc10 nrlc281_1 75.0907519437
Lrlc281 nrlc281_1 nrlc281_2 1
Crlc281 nrlc281_2 rlc13 1.97053695522e-07
* RLC[283] rlc10-rlc15
Rrlc283 rlc10 nrlc283_1 228.687523194
Lrlc283 nrlc283_1 nrlc283_2 0.225390683856
Crlc283 nrlc283_2 rlc15 4.78859943615e-09
* RLC[284] rlc10-GND
Rrlc284 rlc10 nrlc284_1 0.514442610059
Lrlc284 nrlc284_1 nrlc284_2 0.0995621334086
Crlc284 nrlc284_2 GND 0.000418001479214
* RLC[285] rlc11-rlc12
Rrlc285 rlc11 nrlc285_1 1.05409255339
Lrlc285 nrlc285_1 nrlc285_2 1
Crlc285 nrlc285_2 rlc12 0.001
* RLC[286] rlc11-rlc13
Rrlc286 rlc11 nrlc286_1 129.860776577
Lrlc286 nrlc286_1 nrlc286_2 8.41911638554e-06
Crlc286 nrlc286_2 rlc13 5.54712576648e-13
* RLC[287] rlc11-rlc14
Rrlc287 rlc11 nrlc287_1 0.01
Lrlc287 nrlc287_1 nrlc287_2 1.78154645369e-07
Crlc287 nrlc287_2 rlc14 6.97986342047e-06
* RLC[298] rlc14-GND
Rrlc298 rlc14 nrlc298_1 0.01
Lrlc298 nrlc298_1 nrlc298_2 2.52590398036e-11
Crlc298 nrlc298_2 GND 6.77464644509e-08
* RLC[299] rlc15-GND
Rrlc299 rlc15 nrlc299_1 56.8711275874
Lrlc299 nrlc299_1 nrlc299_2 1.59642559234e-07
Crlc299 nrlc299_2 GND 5.48431629402e-14
* DC[0] P1A-P2A
Rdc0 P1A ndc0_1 0.0859070902686
Ldc0 ndc0_1 P2A 1.66208258018e-07
* DC[23] P3A-P4A
Rdc23 P3A ndc23_1 0.670119646219
Ldc23 ndc23_1 P4A 2.7269964363e-06
* DC[25] P3A-P2B
Rdc25 P3A ndc25_1 93693.3241041
Ldc25 ndc25_1 P2B 0.0149117556659
* DC[28] P3A-dc0
Rdc28 P3A ndc28_1 21009.9889127
Ldc28 ndc28_1 dc0 0.00334384358977
* DC[29] P3A-dc1
Rdc29 P3A ndc29_1 57999.1567006
Ldc29 ndc29_1 dc1 0.00923085248406
* DC[30] P3A-dc2
Rdc30 P3A ndc30_1 51018.534968
Ldc30 ndc30_1 dc2 0.00811985202947
* DC[33] P4A-P1B
Rdc33 P4A ndc33_1 86500.6078282
Ldc33 ndc33_1 P1B 0.0137669993163
* DC[34] P4A-P2B
Rdc34 P4A ndc34_1 176118.401733
Ldc34 ndc34_1 P2B 0.0280301142052
* DC[35] P4A-P3B
Rdc35 P4A ndc35_1 323389.401164
Ldc35 ndc35_1 P3B 0.0514690217388
* DC[37] P4A-dc0
Rdc37 P4A ndc37_1 44655.0968907
Ldc37 ndc37_1 dc0 0.0071070794044
* DC[38] P4A-dc1
Rdc38 P4A ndc38_1 18968.1490352
Ldc38 ndc38_1 dc1 0.00301887468026
* DC[42] P1B-P2B
Rdc42 P1B ndc42_1 0.0138629753454
Ldc42 ndc42_1 P2B 9.8854230983e-07
* DC[43] P1B-P3B
Rdc43 P1B ndc43_1 0.01
Ldc43 ndc43_1 P3B 7.93553563189e-09
* DC[44] P1B-P4B
Rdc44 P1B ndc44_1 0.01
Ldc44 ndc44_1 P4B 9.30075620226e-07
* DC[45] P1B-dc0
Rdc45 P1B ndc45_1 0.01
Ldc45 ndc45_1 dc0 2.37053428418e-08
* DC[46] P1B-dc1
Rdc46 P1B ndc46_1 0.0194425251689
Ldc46 ndc46_1 dc1 4.88722950373e-06
* DC[47] P1B-dc2
Rdc47 P1B ndc47_1 0.01
Ldc47 ndc47_1 dc2 1.29200872306e-07
* DC[48] P1B-dc3
Rdc48 P1B ndc48_1 0.01
Ldc48 ndc48_1 dc3 6.28142867458e-07
* DC[50] P2B-P3B
Rdc50 P2B ndc50_1 0.01
Ldc50 ndc50_1 P3B 3.56454711106e-07
* DC[51] P2B-P4B
Rdc51 P2B ndc51_1 0.01
Ldc51 ndc51_1 P4B 8.67333407374e-09
* DC[53] P2B-dc1
Rdc53 P2B ndc53_1 0.01
Ldc53 ndc53_1 dc1 3.26182874912e-08
* DC[54] P2B-dc2
Rdc54 P2B ndc54_1 0.01
Ldc54 ndc54_1 dc2 1.59154943092e-09
* DC[55] P2B-dc3
Rdc55 P2B ndc55_1 0.01
Ldc55 ndc55_1 dc3 1.59154943092e-09
* DC[56] P2B-GND
Rdc56 P2B ndc56_1 374314598520
Ldc56 ndc56_1 GND 1
* DC[57] P3B-P4B
Rdc57 P3B ndc57_1 0.01
Ldc57 ndc57_1 P4B 4.62423500701e-08
* DC[58] P3B-dc0
Rdc58 P3B ndc58_1 0.01
Ldc58 ndc58_1 dc0 1.59154943092e-09
* DC[59] P3B-dc1
Rdc59 P3B ndc59_1 0.01
Ldc59 ndc59_1 dc1 2.60516913932e-07
* DC[60] P3B-dc2
Rdc60 P3B ndc60_1 0.01
Ldc60 ndc60_1 dc2 6.98840184219e-07
* DC[63] P4B-dc0
Rdc63 P4B ndc63_1 0.01
Ldc63 ndc63_1 dc0 3.9772659735e-07
* DC[64] P4B-dc1
Rdc64 P4B ndc64_1 0.01
Ldc64 ndc64_1 dc1 1.59154943092e-09
* DC[65] P4B-dc2
Rdc65 P4B ndc65_1 0.01
Ldc65 ndc65_1 dc2 4.05410661201e-08
* DC[66] P4B-dc3
Rdc66 P4B ndc66_1 0.01
Ldc66 ndc66_1 dc3 2.10944122005e-08
* DC[68] dc0-dc1
Rdc68 dc0 ndc68_1 0.01
Ldc68 ndc68_1 dc1 0.00152316410576
* DC[70] dc0-dc3
Rdc70 dc0 ndc70_1 0.01
Ldc70 ndc70_1 dc3 5.41184684915e-06
* ---- leaks
Rleak_P1A P1A GND 1e+12
Rleak_P1B P1B GND 1e+12
Rleak_P2A P2A GND 1e+12
Rleak_P2B P2B GND 1e+12
Rleak_P3A P3A GND 1e+12
Rleak_P3B P3B GND 1e+12
Rleak_P4A P4A GND 1e+12
Rleak_P4B P4B GND 1e+12
Rleak_dc0 dc0 GND 1e+12
Rleak_dc1 dc1 GND 1e+12
Rleak_dc2 dc2 GND 1e+12
Rleak_dc3 dc3 GND 1e+12
Rleak_rlc0 rlc0 GND 1e+12
Rleak_rlc1 rlc1 GND 1e+12
Rleak_rlc10 rlc10 GND 1e+12
Rleak_rlc11 rlc11 GND 1e+12
Rleak_rlc12 rlc12 GND 1e+12
Rleak_rlc13 rlc13 GND 1e+12
Rleak_rlc14 rlc14 GND 1e+12
Rleak_rlc15 rlc15 GND 1e+12
Rleak_rlc2 rlc2 GND 1e+12
Rleak_rlc3 rlc3 GND 1e+12
Rleak_rlc4 rlc4 GND 1e+12
Rleak_rlc5 rlc5 GND 1e+12
Rleak_rlc6 rlc6 GND 1e+12
Rleak_rlc7 rlc7 GND 1e+12
Rleak_rlc8 rlc8 GND 1e+12
Rleak_rlc9 rlc9 GND 1e+12
.ends fitted
