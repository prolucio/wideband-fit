* fitted: 4-port fitted model, reference z0 = 50 Ohm
* port p is PpA (+) to PpB (-); the reference node is P1B
.subckt fitted P1A P1B P2A P2B P3A P3B P4A P4B
* ---- branches
* RLC[2] P1A-P4A
Rrlc2 P1A nrlc2_1 5370.76317911
Lrlc2 nrlc2_1 nrlc2_2 3.17582112515e-10
Crlc2 nrlc2_2 P4A 2.43584208826e-14
* RLC[4] P1A-P2B
Rrlc4 P1A nrlc4_1 317332998600
Lrlc4 nrlc4_1 nrlc4_2 2.30778294462e-08
Crlc4 nrlc4_2 P2B 3.57167824913e-09
* RLC[5] P1A-P3B
Rrlc5 P1A nrlc5_1 5877403.63287
Lrlc5 nrlc5_1 nrlc5_2 7.79265781688e-07
Crlc5 nrlc5_2 P3B 1.97514140709e-13
* RLC[8] P1A-rlc1
Rrlc8 P1A nrlc8_1 124506104443
Lrlc8 nrlc8_1 nrlc8_2 0.998905893742
Crlc8 nrlc8_2 rlc1 1.26233317084e-08
* RLC[9] P1A-rlc2
Rrlc9 P1A nrlc9_1 45.5307777157
Lrlc9 nrlc9_1 nrlc9_2 1.88234128123e-06
Crlc9 nrlc9_2 rlc2 1.00889442019e-12
* RLC[13] P1A-rlc6
Rrlc13 P1A nrlc13_1 50288.1886512
Lrlc13 nrlc13_1 nrlc13_2 0.000515725649895
Crlc13 nrlc13_2 rlc6 3.06604947435e-13
* RLC[14] P1A-rlc7
Rrlc14 P1A nrlc14_1 4743.43737091
Lrlc14 nrlc14_1 nrlc14_2 0.00075445466251
Crlc14 nrlc14_2 rlc7 3.725669236e-14
* RLC[16] P1A-rlc9
Rrlc16 P1A nrlc16_1 3853.58255534
Lrlc16 nrlc16_1 nrlc16_2 0.000686563643205
Crlc16 nrlc16_2 rlc9 5.13699280778e-14
* RLC[17] P1A-rlc10
Rrlc17 P1A nrlc17_1 99.374616799
Lrlc17 nrlc17_1 nrlc17_2 4.04725209713e-06
Crlc17 nrlc17_2 rlc10 4.55372514061e-13
* RLC[19] P1A-rlc12
Rrlc19 P1A nrlc19_1 52.2075193013
Lrlc19 nrlc19_1 nrlc19_2 2.18256547189e-06
Crlc19 nrlc19_2 rlc12 8.8973086277e-13
* RLC[21] P1A-rlc14
Rrlc21 P1A nrlc21_1 11364.1034888
Lrlc21 nrlc21_1 nrlc21_2 0.00319340407903
Crlc21 nrlc21_2 rlc14 2.74752090928e-14
* RLC[24] P2A-P3A
Rrlc24 P2A nrlc24_1 3711.91626125
Lrlc24 nrlc24_1 nrlc24_2 0.000127310952749
Crlc24 nrlc24_2 P3A 1.02666065412e-14
* RLC[31] P2A-rlc1
Rrlc31 P2A nrlc31_1 503.540103749
Lrlc31 nrlc31_1 nrlc31_2 1.29056193241e-06
Crlc31 nrlc31_2 rlc1 6.73569059097e-13
* RLC[35] P2A-rlc5
Rrlc35 P2A nrlc35_1 1939.17774535
Lrlc35 nrlc35_1 nrlc35_2 6.89686309019e-05
Crlc35 nrlc35_2 rlc5 2.03785771838e-14
* RLC[36] P2A-rlc6
Rrlc36 P2A nrlc36_1 421384.72404
Lrlc36 nrlc36_1 nrlc36_2 6.32081816985e-08
Crlc36 nrlc36_2 rlc6 3.46096360004e-13
* RLC[37] P2A-rlc7
Rrlc37 P2A nrlc37_1 5217.67246385
Lrlc37 nrlc37_1 nrlc37_2 7.43678928777e-05
Crlc37 nrlc37_2 rlc7 2.3482751831e-13
* RLC[38] P2A-rlc8
Rrlc38 P2A nrlc38_1 4.92606328625
Lrlc38 nrlc38_1 nrlc38_2 1.69914369624e-07
Crlc38 nrlc38_2 rlc8 7.78014381858e-12
* RLC[39] P2A-rlc9
Rrlc39 P2A nrlc39_1 11345.5723419
Lrlc39 nrlc39_1 nrlc39_2 0.00284961897119
Crlc39 nrlc39_2 rlc9 2.45975280989e-14
* RLC[40] P2A-rlc10
Rrlc40 P2A nrlc40_1 8367.72724913
Lrlc40 nrlc40_1 nrlc40_2 0.00190794134147
Crlc40 nrlc40_2 rlc10 3.02766261058e-14
* RLC[43] P2A-rlc13
Rrlc43 P2A nrlc43_1 388.26156768
Lrlc43 nrlc43_1 nrlc43_2 1.34948504928e-05
Crlc43 nrlc43_2 rlc13 9.94664826206e-14
* RLC[44] P2A-rlc14
Rrlc44 P2A nrlc44_1 51554.9729881
Lrlc44 nrlc44_1 nrlc44_2 0.0130600564308
Crlc44 nrlc44_2 rlc14 5.45960743767e-15
* RLC[47] P3A-P4A
Rrlc47 P3A nrlc47_1 2.7844492736
Lrlc47 nrlc47_1 nrlc47_2 7.25414867642e-07
Crlc47 nrlc47_2 P4A 1.65277914503e-06
* RLC[48] P3A-P1B
Rrlc48 P3A nrlc48_1 12596.30095
Lrlc48 nrlc48_1 nrlc48_2 0.000141851681099
Crlc48 nrlc48_2 P1B 3.28394395663e-13
* RLC[56] P3A-rlc4
Rrlc56 P3A nrlc56_1 11.5780848332
Lrlc56 nrlc56_1 nrlc56_2 4.05580026986e-07
Crlc56 nrlc56_2 rlc4 3.36171270632e-12
* RLC[58] P3A-rlc6
Rrlc58 P3A nrlc58_1 294807.715279
Lrlc58 nrlc58_1 nrlc58_2 1
Crlc58 nrlc58_2 rlc6 1.27843838095e-14
* RLC[61] P3A-rlc9
Rrlc61 P3A nrlc61_1 6734140.37186
Lrlc61 nrlc61_1 nrlc61_2 2.43736698496e-05
Crlc61 nrlc61_2 rlc9 2.08724250521e-13
* RLC[63] P3A-rlc11
Rrlc63 P3A nrlc63_1 6.46065313882
Lrlc63 nrlc63_1 nrlc63_2 2.28983668361e-07
Crlc63 nrlc63_2 rlc11 6.09549737842e-12
* RLC[66] P3A-rlc14
Rrlc66 P3A nrlc66_1 332158.999537
Lrlc66 nrlc66_1 nrlc66_2 1
Crlc66 nrlc66_2 rlc14 1.00708341307e-14
* RLC[67] P3A-rlc15
Rrlc67 P3A nrlc67_1 164.620921718
Lrlc67 nrlc67_1 nrlc67_2 5.87686025392e-06
Crlc67 nrlc67_2 rlc15 2.40953254347e-13
* RLC[68] P3A-P1B
Rrlc68 P3A nrlc68_1 136.284893953
Lrlc68 nrlc68_1 nrlc68_2 3.08764774682e-07
Crlc68 nrlc68_2 P1B 3.07443858758e-12
* RLC[69] P4A-P1B
Rrlc69 P4A nrlc69_1 687.629861637
Lrlc69 nrlc69_1 nrlc69_2 2.98218142004e-05
Crlc69 nrlc69_2 P1B 7.00780637263e-14
* RLC[72] P4A-P4B
Rrlc72 P4A nrlc72_1 1385258.48715
Lrlc72 nrlc72_1 nrlc72_2 0.166932691344
Crlc72 nrlc72_2 P4B 1.76059198032e-13
* RLC[73] P4A-rlc0
Rrlc73 P4A nrlc73_1 17.2351614178
Lrlc73 nrlc73_1 nrlc73_2 7.27809257068e-07
Crlc73 nrlc73_2 rlc0 2.72235247971e-12
* RLC[75] P4A-rlc2
Rrlc75 P4A nrlc75_1 24989.9807349
Lrlc75 nrlc75_1 nrlc75_2 0.00995774947474
Crlc75 nrlc75_2 rlc2 1.77168636835e-14
* RLC[76] P4A-rlc3
Rrlc76 P4A nrlc76_1 115422.777483
Lrlc76 nrlc76_1 nrlc76_2 1.7235309082e-06
Crlc76 nrlc76_2 rlc3 3.84590034826e-13
* RLC[79] P4A-rlc6
Rrlc79 P4A nrlc79_1 2577.80609339
Lrlc79 nrlc79_1 nrlc79_2 0.000111264799497
Crlc79 nrlc79_2 rlc6 1.86043623e-14
* RLC[81] P4A-rlc8
Rrlc81 P4A nrlc81_1 28.2956148079
Lrlc81 nrlc81_1 nrlc81_2 1.22980832156e-06
Crlc81 nrlc81_2 rlc8 1.70669787787e-12
* RLC[82] P4A-rlc9
Rrlc82 P4A nrlc82_1 4186218.66952
Lrlc82 nrlc82_1 nrlc82_2 0.113217253843
Crlc82 nrlc82_2 rlc9 1.49212407707e-13
* RLC[83] P4A-rlc10
Rrlc83 P4A nrlc83_1 95940.114945
Lrlc83 nrlc83_1 nrlc83_2 0.000456706401359
Crlc83 nrlc83_2 rlc10 2.76291968095e-13
* RLC[88] P4A-rlc15
Rrlc88 P4A nrlc88_1 2100.98411075
Lrlc88 nrlc88_1 nrlc88_2 8.80874673074e-05
Crlc88 nrlc88_2 rlc15 2.21730827599e-14
* RLC[89] P4A-P1B
Rrlc89 P4A nrlc89_1 127393426038
Lrlc89 nrlc89_1 nrlc89_2 2.29330567765e-07
Crlc89 nrlc89_2 P1B 5.24013709784e-10
* RLC[91] P1B-P3B
Rrlc91 P1B nrlc91_1 148.716475202
Lrlc91 nrlc91_1 nrlc91_2 1.46481037715e-08
Crlc91 nrlc91_2 P3B 8.57967999571e-12
* RLC[92] P1B-P4B
Rrlc92 P1B nrlc92_1 1.29231848025
Lrlc92 nrlc92_1 nrlc92_2 4.12005041585e-09
Crlc92 nrlc92_2 P4B 3.16023068102e-10
* RLC[93] P1B-rlc0
Rrlc93 P1B nrlc93_1 26.5131888411
Lrlc93 nrlc93_1 nrlc93_2 8.04662649632e-06
Crlc93 nrlc93_2 rlc0 1.27188370501e-11
* RLC[96] P1B-rlc3
Rrlc96 P1B nrlc96_1 96.1559916183
Lrlc96 nrlc96_1 nrlc96_2 0.00359257760695
Crlc96 nrlc96_2 rlc3 0.001
* RLC[97] P1B-rlc4
Rrlc97 P1B nrlc97_1 0.413101795536
Lrlc97 nrlc97_1 nrlc97_2 2.89991990016e-08
Crlc97 nrlc97_2 rlc4 8.67019204211e-09
* RLC[99] P1B-rlc6
Rrlc99 P1B nrlc99_1 0.162620528766
Lrlc99 nrlc99_1 nrlc99_2 1.31631096153e-05
Crlc99 nrlc99_2 rlc6 0.000189098170799
* RLC[106] P1B-rlc13
Rrlc106 P1B nrlc106_1 1.6066018222
Lrlc106 nrlc106_1 nrlc106_2 0.000284785806756
Crlc106 nrlc106_2 rlc13 0.000312421267688
* RLC[107] P1B-rlc14
Rrlc107 P1B nrlc107_1 2.14326501718
Lrlc107 nrlc107_1 nrlc107_2 8.21484548909e-08
Crlc107 nrlc107_2 rlc14 1.87842786706e-09
* RLC[111] P2B-P4B
Rrlc111 P2B nrlc111_1 331.352358815
Lrlc111 nrlc111_1 nrlc111_2 5.33118932349e-12
Crlc111 nrlc111_2 P4B 6.66247111724e-09
* RLC[114] P2B-rlc2
Rrlc114 P2B nrlc114_1 12504.5335336
Lrlc114 nrlc114_1 nrlc114_2 0.357767373117
Crlc114 nrlc114_2 rlc2 2.46406760616e-05
* RLC[115] P2B-rlc3
Rrlc115 P2B nrlc115_1 0.01
Lrlc115 nrlc115_1 nrlc115_2 8.1825317372e-07
Crlc115 nrlc115_2 rlc3 6.83430747303e-05
* RLC[118] P2B-rlc6
Rrlc118 P2B nrlc118_1 199.840250125
Lrlc118 nrlc118_1 nrlc118_2 2.54380462505e-05
Crlc118 nrlc118_2 rlc6 5.02207722232e-10
* RLC[120] P2B-rlc8
Rrlc120 P2B nrlc120_1 0.01
Lrlc120 nrlc120_1 nrlc120_2 4.59809269699e-07
Crlc120 nrlc120_2 rlc8 0.001
* RLC[121] P2B-rlc9
Rrlc121 P2B nrlc121_1 0.0898247300302
Lrlc121 nrlc121_1 nrlc121_2 5.1851882586e-11
Crlc121 nrlc121_2 rlc9 1.25349626021e-07
* RLC[122] P2B-rlc10
Rrlc122 P2B nrlc122_1 4.28709572901
Lrlc122 nrlc122_1 nrlc122_2 3.0238116442e-10
Crlc122 nrlc122_2 rlc10 2.82100732565e-08
* RLC[125] P2B-rlc13
Rrlc125 P2B nrlc125_1 745.140206792
Lrlc125 nrlc125_1 nrlc125_2 0.0955134382657
Crlc125 nrlc125_2 rlc13 5.50571928914e-05
* RLC[126] P2B-rlc14
Rrlc126 P2B nrlc126_1 58.9807517803
Lrlc126 nrlc126_1 nrlc126_2 0.000398961021948
Crlc126 nrlc126_2 rlc14 4.10617388566e-07
* RLC[129] P3B-P4B
Rrlc129 P3B nrlc129_1 0.791101780494
Lrlc129 nrlc129_1 nrlc129_2 1.85958467691e-06
Crlc129 nrlc129_2 P4B 0.000894638807648
* RLC[131] P3B-rlc1
Rrlc131 P3B nrlc131_1 25730.4281617
Lrlc131 nrlc131_1 nrlc131_2 1
Crlc131 nrlc131_2 rlc1 0.001
* RLC[136] P3B-rlc6
Rrlc136 P3B nrlc136_1 0.01
Lrlc136 nrlc136_1 nrlc136_2 2.07961441161e-07
Crlc136 nrlc136_2 rlc6 0.000965922899118
* RLC[139] P3B-rlc9
Rrlc139 P3B nrlc139_1 4753.74298123
Lrlc139 nrlc139_1 nrlc139_2 7.92405115906e-07
Crlc139 nrlc139_2 rlc9 2.78679794556e-10
* RLC[140] P3B-rlc10
Rrlc140 P3B nrlc140_1 0.349008600769
Lrlc140 nrlc140_1 nrlc140_2 2.26113873394e-06
Crlc140 nrlc140_2 rlc10 7.02736305088e-07
* RLC[144] P3B-rlc14
Rrlc144 P3B nrlc144_1 40740.4136568
Lrlc144 nrlc144_1 nrlc144_2 1
Crlc144 nrlc144_2 rlc14 0.000125994243399
* RLC[147] P4B-rlc0
Rrlc147 P4B nrlc147_1 5.26554986237
Lrlc147 nrlc147_1 nrlc147_2 5.4817095243e-06
Crlc147 nrlc147_2 rlc0 0.000139884970246
* RLC[148] P4B-rlc1
Rrlc148 P4B nrlc148_1 6.14482031706
Lrlc148 nrlc148_1 nrlc148_2 1.81762839422e-08
Crlc148 nrlc148_2 rlc1 8.55726712815e-09
* RLC[149] P4B-rlc2
Rrlc149 P4B nrlc149_1 90.9860908932
Lrlc149 nrlc149_1 nrlc149_2 3.77129362268e-07
Crlc149 nrlc149_2 rlc2 8.21674682507e-05
* RLC[150] P4B-rlc3
Rrlc150 P4B nrlc150_1 600.845229528
Lrlc150 nrlc150_1 nrlc150_2 0.0524826790283
Crlc150 nrlc150_2 rlc3 0.000153212868624
* RLC[152] P4B-rlc5
Rrlc152 P4B nrlc152_1 41.2056183988
Lrlc152 nrlc152_1 nrlc152_2 2.70099672254e-06
Crlc152 nrlc152_2 rlc5 9.44428343502e-12
* RLC[153] P4B-rlc6
Rrlc153 P4B nrlc153_1 66.3881387287
Lrlc153 nrlc153_1 nrlc153_2 5.39979162366e-07
Crlc153 nrlc153_2 rlc6 7.94485114704e-11
* RLC[155] P4B-rlc8
Rrlc155 P4B nrlc155_1 1.93420678279
Lrlc155 nrlc155_1 nrlc155_2 1.23821998687e-06
Crlc155 nrlc155_2 rlc8 1.54251839244e-06
* RLC[159] P4B-rlc12
Rrlc159 P4B nrlc159_1 0.0100044235657
Lrlc159 nrlc159_1 nrlc159_2 2.77056976414e-13
Crlc159 nrlc159_2 rlc12 6.82525633756e-11
* RLC[160] P4B-rlc13
Rrlc160 P4B nrlc160_1 3.08039575274
Lrlc160 nrlc160_1 nrlc160_2 3.74835021704e-05
Crlc160 nrlc160_2 rlc13 8.35830763354e-05
* RLC[162] P4B-rlc15
Rrlc162 P4B nrlc162_1 0.975603759269
Lrlc162 nrlc162_1 nrlc162_2 3.86237852555e-08
Crlc162 nrlc162_2 rlc15 4.50884591644e-11
* RLC[163] P4B-P1B
Rrlc163 P4B nrlc163_1 3.85119424333
Lrlc163 nrlc163_1 nrlc163_2 1.24865647679e-07
Crlc163 nrlc163_2 P1B 0.00012581129515
* RLC[164] rlc0-rlc1
Rrlc164 rlc0 nrlc164_1 11.7681483132
Lrlc164 nrlc164_1 nrlc164_2 2.05732142915e-07
Crlc164 nrlc164_2 rlc1 3.91026522854e-10
* RLC[167] rlc0-rlc4
Rrlc167 rlc0 nrlc167_1 0.993335485142
Lrlc167 nrlc167_1 nrlc167_2 2.43298736818e-07
Crlc167 nrlc167_2 rlc4 2.73971535887e-10
* RLC[169] rlc0-rlc6
Rrlc169 rlc0 nrlc169_1 90.204432875
Lrlc169 nrlc169_1 nrlc169_2 1.80173818333e-06
Crlc169 nrlc169_2 rlc6 1.66443689999e-10
* RLC[170] rlc0-rlc7
Rrlc170 rlc0 nrlc170_1 0.23435379067
Lrlc170 nrlc170_1 nrlc170_2 3.79501765971e-07
Crlc170 nrlc170_2 rlc7 5.15823632938e-06
* RLC[171] rlc0-rlc8
Rrlc171 rlc0 nrlc171_1 71.3916779184
Lrlc171 nrlc171_1 nrlc171_2 2.3878062753e-06
Crlc171 nrlc171_2 rlc8 3.06124414079e-11
* RLC[172] rlc0-rlc9
Rrlc172 rlc0 nrlc172_1 30.5189951291
Lrlc172 nrlc172_1 nrlc172_2 0.0520511715814
Crlc172 nrlc172_2 rlc9 0.000766497561984
* RLC[175] rlc0-rlc12
Rrlc175 rlc0 nrlc175_1 0.238392235617
Lrlc175 nrlc175_1 nrlc175_2 1.11685422277e-07
Crlc175 nrlc175_2 rlc12 2.23529672163e-09
* RLC[177] rlc0-rlc14
Rrlc177 rlc0 nrlc177_1 0.01
Lrlc177 nrlc177_1 nrlc177_2 3.69325900551e-08
Crlc177 nrlc177_2 rlc14 2.33076074432e-05
* RLC[178] rlc0-rlc15
Rrlc178 rlc0 nrlc178_1 13.9811202154
Lrlc178 nrlc178_1 nrlc178_2 5.18132585098e-07
Crlc178 nrlc178_2 rlc15 1.23467007274e-10
* RLC[180] rlc1-rlc2
Rrlc180 rlc1 nrlc180_1 0.867755633135
Lrlc180 nrlc180_1 nrlc180_2 1.43926737955e-07
Crlc180 nrlc180_2 rlc2 2.12375341241e-10
* RLC[181] rlc1-rlc3
Rrlc181 rlc1 nrlc181_1 0.128308933401
Lrlc181 nrlc181_1 nrlc181_2 1.38595262654e-08
Crlc181 nrlc181_2 rlc3 4.20316703826e-08
* RLC[183] rlc1-rlc5
Rrlc183 rlc1 nrlc183_1 142.156781397
Lrlc183 nrlc183_1 nrlc183_2 2.96201101838e-05
Crlc183 nrlc183_2 rlc5 1.62857962238e-12
* RLC[184] rlc1-rlc6
Rrlc184 rlc1 nrlc184_1 4.54999570661
Lrlc184 nrlc184_1 nrlc184_2 1.42014880262e-07
Crlc184 nrlc184_2 rlc6 6.89133955881e-07
* RLC[185] rlc1-rlc7
Rrlc185 rlc1 nrlc185_1 35.9429621216
Lrlc185 nrlc185_1 nrlc185_2 2.04557511755e-07
Crlc185 nrlc185_2 rlc7 3.56521847957e-11
* RLC[186] rlc1-rlc8
Rrlc186 rlc1 nrlc186_1 41.3565220391
Lrlc186 nrlc186_1 nrlc186_2 8.57284153186e-07
Crlc186 nrlc186_2 rlc8 2.10182429031e-10
* RLC[189] rlc1-rlc11
Rrlc189 rlc1 nrlc189_1 7.80608945569
Lrlc189 nrlc189_1 nrlc189_2 6.90048113245e-07
Crlc189 nrlc189_2 rlc11 0.000331785252291
* RLC[191] rlc1-rlc13
Rrlc191 rlc1 nrlc191_1 6.87176631449
Lrlc191 nrlc191_1 nrlc191_2 5.22645563925e-07
Crlc191 nrlc191_2 rlc13 2.41850794144e-07
* RLC[195] rlc2-rlc3
Rrlc195 rlc2 nrlc195_1 22.2494068369
Lrlc195 nrlc195_1 nrlc195_2 2.00446341718e-06
Crlc195 nrlc195_2 rlc3 1.20649407347e-09
* RLC[197] rlc2-rlc5
Rrlc197 rlc2 nrlc197_1 107.296233227
Lrlc197 nrlc197_1 nrlc197_2 4.93352324799e-06
Crlc197 nrlc197_2 rlc5 2.45063922065e-10
* RLC[198] rlc2-rlc6
Rrlc198 rlc2 nrlc198_1 261.537512272
Lrlc198 nrlc198_1 nrlc198_2 4.06612797643e-06
Crlc198 nrlc198_2 rlc6 6.15275153365e-11
* RLC[199] rlc2-rlc7
Rrlc199 rlc2 nrlc199_1 0.0413769496627
Lrlc199 nrlc199_1 nrlc199_2 3.08067060921e-07
Crlc199 nrlc199_2 rlc7 1.99933612809e-07
* RLC[200] rlc2-rlc8
Rrlc200 rlc2 nrlc200_1 125.458119408
Lrlc200 nrlc200_1 nrlc200_2 1.53426133057e-05
Crlc200 nrlc200_2 rlc8 1.09883875923e-11
* RLC[201] rlc2-rlc9
Rrlc201 rlc2 nrlc201_1 10.5989777101
Lrlc201 nrlc201_1 nrlc201_2 0.000394682205366
Crlc201 nrlc201_2 rlc9 3.5552521808e-05
* RLC[205] rlc2-rlc13
Rrlc205 rlc2 nrlc205_1 0.200735210351
Lrlc205 nrlc205_1 nrlc205_2 1.22381617371e-09
Crlc205 nrlc205_2 rlc13 4.35227480991e-11
* RLC[209] rlc3-rlc4
Rrlc209 rlc3 nrlc209_1 5.98230916156
Lrlc209 nrlc209_1 nrlc209_2 3.57329289084e-07
Crlc209 nrlc209_2 rlc4 1.49740835073e-10
* RLC[210] rlc3-rlc5
Rrlc210 rlc3 nrlc210_1 9.65388367178
Lrlc210 nrlc210_1 nrlc210_2 9.74083725405e-06
Crlc210 nrlc210_2 rlc5 2.62951308985e-06
* RLC[211] rlc3-rlc6
Rrlc211 rlc3 nrlc211_1 2.69476679737
Lrlc211 nrlc211_1 nrlc211_2 1.18852646536e-07
Crlc211 nrlc211_2 rlc6 1.81854466397e-11
* RLC[212] rlc3-rlc7
Rrlc212 rlc3 nrlc212_1 0.0289956997136
Lrlc212 nrlc212_1 nrlc212_2 6.64836141023e-06
Crlc212 nrlc212_2 rlc7 1.56522193327e-05
* RLC[213] rlc3-rlc8
Rrlc213 rlc3 nrlc213_1 76.2853846044
Lrlc213 nrlc213_1 nrlc213_2 5.83411600944e-06
Crlc213 nrlc213_2 rlc8 5.76568009303e-12
* RLC[214] rlc3-rlc9
Rrlc214 rlc3 nrlc214_1 30.889921747
Lrlc214 nrlc214_1 nrlc214_2 0.000102668258298
Crlc214 nrlc214_2 rlc9 7.68068637928e-07
* RLC[219] rlc3-rlc14
Rrlc219 rlc3 nrlc219_1 6.05289813126
Lrlc219 nrlc219_1 nrlc219_2 9.31881230473e-08
Crlc219 nrlc219_2 rlc14 1.06141579465e-07
* RLC[220] rlc3-rlc15
Rrlc220 rlc3 nrlc220_1 35.3149014731
Lrlc220 nrlc220_1 nrlc220_2 1.63088252011e-06
Crlc220 nrlc220_2 rlc15 7.12805968493e-11
* RLC[221] rlc3-P1B
Rrlc221 rlc3 nrlc221_1 0.764145381991
Lrlc221 nrlc221_1 nrlc221_2 4.09839672598e-09
Crlc221 nrlc221_2 P1B 4.79210323078e-06
* RLC[222] rlc4-rlc5
Rrlc222 rlc4 nrlc222_1 75.0022026388
Lrlc222 nrlc222_1 nrlc222_2 6.95813770782e-06
Crlc222 nrlc222_2 rlc5 4.46546205336e-12
* RLC[223] rlc4-rlc6
Rrlc223 rlc4 nrlc223_1 124.556295938
Lrlc223 nrlc223_1 nrlc223_2 2.79874855149e-06
Crlc223 nrlc223_2 rlc6 8.56300602635e-11
* RLC[225] rlc4-rlc8
Rrlc225 rlc4 nrlc225_1 11.544099133
Lrlc225 nrlc225_1 nrlc225_2 1.39631533454e-07
Crlc225 nrlc225_2 rlc8 3.20527344289e-09
* RLC[228] rlc4-rlc11
Rrlc228 rlc4 nrlc228_1 1.32413190406
Lrlc228 nrlc228_1 nrlc228_2 4.90907322238e-07
Crlc228 nrlc228_2 rlc11 4.99841018606e-06
* RLC[229] rlc4-rlc12
Rrlc229 rlc4 nrlc229_1 1.47206546748
Lrlc229 nrlc229_1 nrlc229_2 2.91384573941e-07
Crlc229 nrlc229_2 rlc12 1.89827054376e-10
* RLC[231] rlc4-rlc14
Rrlc231 rlc4 nrlc231_1 6.01774482879
Lrlc231 nrlc231_1 nrlc231_2 9.88675157354e-08
Crlc231 nrlc231_2 rlc14 3.75299498145e-09
* RLC[233] rlc4-P1B
Rrlc233 rlc4 nrlc233_1 2.27900539352
Lrlc233 nrlc233_1 nrlc233_2 6.08114011696e-06
Crlc233 nrlc233_2 P1B 0.000814853579703
* RLC[235] rlc5-rlc7
Rrlc235 rlc5 nrlc235_1 27.102043951
Lrlc235 nrlc235_1 nrlc235_2 5.38174939931e-06
Crlc235 nrlc235_2 rlc7 6.07615676692e-08
* RLC[237] rlc5-rlc9
Rrlc237 rlc5 nrlc237_1 24.1403456389
Lrlc237 nrlc237_1 nrlc237_2 0.117975672808
Crlc237 nrlc237_2 rlc9 0.001
* RLC[240] rlc5-rlc12
Rrlc240 rlc5 nrlc240_1 87.3540708505
Lrlc240 nrlc240_1 nrlc240_2 0.00457249874198
Crlc240 nrlc240_2 rlc12 0.001
* RLC[243] rlc5-rlc15
Rrlc243 rlc5 nrlc243_1 349.541492932
Lrlc243 nrlc243_1 nrlc243_2 1.03138342619e-06
Crlc243 nrlc243_2 rlc15 1.81009958011e-11
* RLC[246] rlc6-rlc8
Rrlc246 rlc6 nrlc246_1 85.6076360587
Lrlc246 nrlc246_1 nrlc246_2 9.64951523285e-07
Crlc246 nrlc246_2 rlc8 8.59577841873e-11
* RLC[247] rlc6-rlc9
Rrlc247 rlc6 nrlc247_1 220.231617275
Lrlc247 nrlc247_1 nrlc247_2 7.88453409252e-06
Crlc247 nrlc247_2 rlc9 2.06872643655e-10
* RLC[248] rlc6-rlc10
Rrlc248 rlc6 nrlc248_1 0.1063372778
Lrlc248 nrlc248_1 nrlc248_2 0.000373366305681
Crlc248 nrlc248_2 rlc10 0.000182986318503
* RLC[255] rlc7-rlc8
Rrlc255 rlc7 nrlc255_1 5.75598799405
Lrlc255 nrlc255_1 nrlc255_2 5.89487579179e-07
Crlc255 nrlc255_2 rlc8 3.7470052416e-11
* RLC[260] rlc7-rlc13
Rrlc260 rlc7 nrlc260_1 70.1540494069
Lrlc260 nrlc260_1 nrlc260_2 5.39772367913e-11
Crlc260 nrlc260_2 rlc13 3.89075477039e-11
* RLC[261] rlc7-rlc14
Rrlc261 rlc7 nrlc261_1 28.0095064906
Lrlc261 nrlc261_1 nrlc261_2 3.96088472946e-06
Crlc261 nrlc261_2 rlc14 5.60968894422e-12
* RLC[262] rlc7-rlc15
Rrlc262 rlc7 nrlc262_1 7.01774321321
Lrlc262 nrlc262_1 nrlc262_2 7.57108203462e-07
Crlc262 nrlc262_2 rlc15 4.34596753005e-09
* RLC[266] rlc8-rlc11
Rrlc266 rlc8 nrlc266_1 4.7568879308
Lrlc266 nrlc266_1 nrlc266_2 6.0000993114e-11
Crlc266 nrlc266_2 rlc11 1.97451009047e-09
* RLC[268] rlc8-rlc13
Rrlc268 rlc8 nrlc268_1 45.9331797051
Lrlc268 nrlc268_1 nrlc268_2 1.38327593795e-05
Crlc268 nrlc268_2 rlc13 7.28472719226e-12
* RLC[270] rlc8-rlc15
Rrlc270 rlc8 nrlc270_1 10.5174568168
Lrlc270 nrlc270_1 nrlc270_2 7.29161745599e-07
Crlc270 nrlc270_2 rlc15 1.25492973825e-10
* RLC[271] rlc8-P1B
Rrlc271 rlc8 nrlc271_1 2.53713368402
Lrlc271 nrlc271_1 nrlc271_2 9.7503403056e-08
Crlc271 nrlc271_2 P1B 1.52261730784e-07
* RLC[275] rlc9-rlc13
Rrlc275 rlc9 nrlc275_1 157.274535505
Lrlc275 nrlc275_1 nrlc275_2 5.54086697939e-10
Crlc275 nrlc275_2 rlc13 7.3831837283e-12
* RLC[277] rlc9-rlc15
Rrlc277 rlc9 nrlc277_1 106.710034415
Lrlc277 nrlc277_1 nrlc277_2 8.14590792126e-06
Crlc277 nrlc277_2 rlc15 7.94852358596e-13
* RLC[283] rlc10-rlc15
Rrlc283 rlc10 nrlc283_1 26.6631157415
Lrlc283 nrlc283_1 nrlc283_2 7.81363168023e-07
Crlc283 nrlc283_2 rlc15 4.8245839084e-09
* RLC[284] rlc10-P1B
Rrlc284 rlc10 nrlc284_1 2.84749930612
Lrlc284 nrlc284_1 nrlc284_2 5.56851719313e-07
Crlc284 nrlc284_2 P1B 0.001
* RLC[285] rlc11-rlc12
Rrlc285 rlc11 nrlc285_1 0.0188856578643
Lrlc285 nrlc285_1 nrlc285_2 8.35118745855e-07
Crlc285 nrlc285_2 rlc12 8.87640620926e-05
* RLC[287] rlc11-rlc14
Rrlc287 rlc11 nrlc287_1 10.2116015211
Lrlc287 nrlc287_1 nrlc287_2 2.07902678859e-07
Crlc287 nrlc287_2 rlc14 4.46454764942e-09
* RLC[288] rlc11-rlc15
Rrlc288 rlc11 nrlc288_1 6.06005081653
Lrlc288 nrlc288_1 nrlc288_2 2.46408326411e-08
Crlc288 nrlc288_2 rlc15 1.55506467563e-11
* RLC[289] rlc11-P1B
Rrlc289 rlc11 nrlc289_1 2.47061175702
Lrlc289 nrlc289_1 nrlc289_2 4.71573965919e-05
Crlc289 nrlc289_2 P1B 0.001
* RLC[290] rlc12-rlc13
Rrlc290 rlc12 nrlc290_1 0.0864171014829
Lrlc290 nrlc290_1 nrlc290_2 4.32486793724e-05
Crlc290 nrlc290_2 rlc13 0.001
* RLC[292] rlc12-rlc15
Rrlc292 rlc12 nrlc292_1 15.7659374166
Lrlc292 nrlc292_1 nrlc292_2 9.57113081865e-12
Crlc292 nrlc292_2 rlc15 3.39266527757e-07
* RLC[295] rlc13-rlc15
Rrlc295 rlc13 nrlc295_1 6.8911626737
Lrlc295 nrlc295_1 nrlc295_2 6.22684930657e-07
Crlc295 nrlc295_2 rlc15 2.28581086237e-09
* RLC[296] rlc13-P1B
Rrlc296 rlc13 nrlc296_1 56.3817502859
Lrlc296 nrlc296_1 nrlc296_2 2.35927956385e-06
Crlc296 nrlc296_2 P1B 3.73828159848e-10
* RLC[298] rlc14-P1B
Rrlc298 rlc14 nrlc298_1 3.02999072085
Lrlc298 nrlc298_1 nrlc298_2 5.66987381638e-07
Crlc298 nrlc298_2 P1B 7.08877969322e-11
* RLC[299] rlc15-P1B
Rrlc299 rlc15 nrlc299_1 61.2621718592
Lrlc299 nrlc299_1 nrlc299_2 1.85638832335e-06
Crlc299 nrlc299_2 P1B 5.07300822392e-11
* DC[0] P1A-P2A
Rdc0 P1A ndc0_1 0.022210519889
Ldc0 ndc0_1 P2A 6.06087914084e-08
* DC[23] P3A-P4A
Rdc23 P3A ndc23_1 0.0247790309743
Ldc23 ndc23_1 P4A 1.12862241536e-07
* DC[42] P1B-P2B
Rdc42 P1B ndc42_1 0.140729788422
Ldc42 ndc42_1 P2B 3.94006622129e-07
* DC[43] P1B-P3B
Rdc43 P1B ndc43_1 5.93640966414
Ldc43 ndc43_1 P3B 1.33899814826e-05
* DC[45] P1B-dc0
Rdc45 P1B ndc45_1 0.0100993499067
Ldc45 ndc45_1 dc0 2.24761976857e-05
* DC[46] P1B-dc1
Rdc46 P1B ndc46_1 0.01
Ldc46 ndc46_1 dc1 0.000684185607496
* DC[47] P1B-dc2
Rdc47 P1B ndc47_1 0.0100625639495
Ldc47 ndc47_1 dc2 8.95329590655e-05
* DC[48] P1B-dc3
Rdc48 P1B ndc48_1 2.09235291567
Ldc48 ndc48_1 dc3 3.71234930767e-07
* DC[50] P2B-P3B
Rdc50 P2B ndc50_1 8808.00339707
Ldc50 ndc50_1 P3B 1
* DC[51] P2B-P4B
Rdc51 P2B ndc51_1 105.151353553
Ldc51 ndc51_1 P4B 1.67353576907e-05
* DC[53] P2B-dc1
Rdc53 P2B ndc53_1 449.719388183
Ldc53 ndc53_1 dc1 0.554177180405
* DC[54] P2B-dc2
Rdc54 P2B ndc54_1 168.681506431
Ldc54 ndc54_1 dc2 2.68464955566e-05
* DC[55] P2B-dc3
Rdc55 P2B ndc55_1 0.352329095529
Ldc55 ndc55_1 dc3 5.60749171485e-08
* DC[56] P2B-P1B
Rdc56 P2B ndc56_1 0.136464935885
Ldc56 ndc56_1 P1B 7.14944641569e-08
* DC[57] P3B-P4B
Rdc57 P3B ndc57_1 0.12975539902
Ldc57 ndc57_1 P4B 6.23755284121e-08
* DC[61] P3B-dc3
Rdc61 P3B ndc61_1 7675.75436025
Ldc61 ndc61_1 dc3 1
* DC[62] P3B-P1B
Rdc62 P3B ndc62_1 0.601097812408
Ldc62 ndc62_1 P1B 1.3558201426e-06
* DC[63] P4B-dc0
Rdc63 P4B ndc63_1 12.5786115187
Ldc63 ndc63_1 dc0 0.00264619182415
* DC[64] P4B-dc1
Rdc64 P4B ndc64_1 0.01
Ldc64 ndc64_1 dc1 0.000244842359173
* DC[65] P4B-dc2
Rdc65 P4B ndc65_1 0.0100254243476
Ldc65 ndc65_1 dc2 0.000839693423909
* DC[69] dc0-dc2
Rdc69 dc0 ndc69_1 1.51449087279
Ldc69 ndc69_1 dc2 2.41038708672e-07
* DC[70] dc0-dc3
Rdc70 dc0 ndc70_1 0.575494881573
Ldc70 ndc70_1 dc3 1.56133592827e-06
* DC[71] dc0-P1B
Rdc71 dc0 ndc71_1 0.0100266199299
Ldc71 ndc71_1 P1B 0.000417346505432
* DC[72] dc1-dc2
Rdc72 dc1 ndc72_1 0.518149071368
Ldc72 ndc72_1 dc2 8.24659859667e-08
* DC[74] dc1-P1B
Rdc74 dc1 ndc74_1 0.01
Ldc74 ndc74_1 P1B 0.000662592860098
* DC[76] dc2-P1B
Rdc76 dc2 ndc76_1 0.0100661022041
Ldc76 ndc76_1 P1B 9.71965470679e-05
* DC[77] dc3-P1B
Rdc77 dc3 ndc77_1 46.6396612869
Ldc77 ndc77_1 P1B 8.275074155e-06
* ---- leaks
Rleak_P1A P1A P1B 1e+12
Rleak_P2A P2A P1B 1e+12
Rleak_P2B P2B P1B 1e+12
Rleak_P3A P3A P1B 1e+12
Rleak_P3B P3B P1B 1e+12
Rleak_P4A P4A P1B 1e+12
Rleak_P4B P4B P1B 1e+12
Rleak_dc0 dc0 P1B 1e+12
Rleak_dc1 dc1 P1B 1e+12
Rleak_dc2 dc2 P1B 1e+12
Rleak_dc3 dc3 P1B 1e+12
Rleak_rlc0 rlc0 P1B 1e+12
Rleak_rlc1 rlc1 P1B 1e+12
Rleak_rlc10 rlc10 P1B 1e+12
Rleak_rlc11 rlc11 P1B 1e+12
Rleak_rlc12 rlc12 P1B 1e+12
Rleak_rlc13 rlc13 P1B 1e+12
Rleak_rlc14 rlc14 P1B 1e+12
Rleak_rlc15 rlc15 P1B 1e+12
Rleak_rlc2 rlc2 P1B 1e+12
Rleak_rlc3 rlc3 P1B 1e+12
Rleak_rlc4 rlc4 P1B 1e+12
Rleak_rlc5 rlc5 P1B 1e+12
Rleak_rlc6 rlc6 P1B 1e+12
Rleak_rlc7 rlc7 P1B 1e+12
Rleak_rlc8 rlc8 P1B 1e+12
Rleak_rlc9 rlc9 P1B 1e+12
.ends fitted
