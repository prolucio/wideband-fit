* fitted: 4-port fitted model, reference z0 = 50 Ohm
* port p is PpA (+) to PpB (-); the reference node is P1B
.subckt fitted P1A P1B P2A P2B P3A P3B P4A P4B
* ---- branches
* RLC[1] P1A-P3A
Rrlc1 P1A nrlc1_1 99418101.4336
Lrlc1 nrlc1_1 nrlc1_2 0.00809333506701
Crlc1 nrlc1_2 P3A 1.91778988407e-14
* RLC[6] P1A-P4B
Rrlc6 P1A nrlc6_1 1815.65004276
Lrlc6 nrlc6_1 nrlc6_2 2.18139926995e-06
Crlc6 nrlc6_2 P4B 3.22258284757e-13
* RLC[7] P1A-rlc0
Rrlc7 P1A nrlc7_1 272.488994255
Lrlc7 nrlc7_1 nrlc7_2 1.05784585657e-05
Crlc7 nrlc7_2 rlc0 1.58300376575e-13
* RLC[8] P1A-rlc1
Rrlc8 P1A nrlc8_1 110504113965
Lrlc8 nrlc8_1 nrlc8_2 0.999899062387
Crlc8 nrlc8_2 rlc1 3.82772605025e-09
* RLC[11] P1A-rlc4
Rrlc11 P1A nrlc11_1 15276.872313
Lrlc11 nrlc11_1 nrlc11_2 0.000216337647842
Crlc11 nrlc11_2 rlc4 1.61803129737e-13
* RLC[13] P1A-rlc6
Rrlc13 P1A nrlc13_1 10.2444394858
Lrlc13 nrlc13_1 nrlc13_2 3.75832606122e-07
Crlc13 nrlc13_2 rlc6 3.97901469688e-12
* RLC[15] P1A-rlc8
Rrlc15 P1A nrlc15_1 634948.763148
Lrlc15 nrlc15_1 nrlc15_2 0.0105147218121
Crlc15 nrlc15_2 rlc8 1.95533935349e-13
* RLC[16] P1A-rlc9
Rrlc16 P1A nrlc16_1 1167.49791407
Lrlc16 nrlc16_1 nrlc16_2 2.51803025124e-12
Crlc16 nrlc16_2 rlc9 2.71051074419e-14
* RLC[20] P1A-rlc13
Rrlc20 P1A nrlc20_1 3724269.71893
Lrlc20 nrlc20_1 nrlc20_2 1.47445524439e-05
Crlc20 nrlc20_2 rlc13 2.08037140361e-13
* RLC[21] P1A-rlc14
Rrlc21 P1A nrlc21_1 5.72412360669
Lrlc21 nrlc21_1 nrlc21_2 3.21725432215e-08
Crlc21 nrlc21_2 rlc14 1.09100031724e-12
* RLC[23] P1A-P1B
Rrlc23 P1A nrlc23_1 3600.862853
Lrlc23 nrlc23_1 nrlc23_2 0.000405986052647
Crlc23 nrlc23_2 P1B 3.47900812749e-14
* RLC[24] P2A-P3A
Rrlc24 P2A nrlc24_1 7774043.9311
Lrlc24 nrlc24_1 nrlc24_2 0.00182195480689
Crlc24 nrlc24_2 P3A 1.13892428447e-14
* RLC[26] P2A-P1B
Rrlc26 P2A nrlc26_1 15165.8494412
Lrlc26 nrlc26_1 nrlc26_2 0.00490958251673
Crlc26 nrlc26_2 P1B 2.37174816835e-14
* RLC[28] P2A-P3B
Rrlc28 P2A nrlc28_1 52095.860044
Lrlc28 nrlc28_1 nrlc28_2 0.00150264868363
Crlc28 nrlc28_2 P3B 1.53033397688e-14
* RLC[30] P2A-rlc0
Rrlc30 P2A nrlc30_1 65365.6363395
Lrlc30 nrlc30_1 nrlc30_2 0.000488997405226
Crlc30 nrlc30_2 rlc0 2.59440970604e-13
* RLC[31] P2A-rlc1
Rrlc31 P2A nrlc31_1 12.1377049557
Lrlc31 nrlc31_1 nrlc31_2 4.59319811645e-07
Crlc31 nrlc31_2 rlc1 3.46417254797e-12
* RLC[33] P2A-rlc3
Rrlc33 P2A nrlc33_1 479521114814
Lrlc33 nrlc33_1 nrlc33_2 1.98512088136e-07
Crlc33 nrlc33_2 rlc3 6.23862027298e-11
* RLC[37] P2A-rlc7
Rrlc37 P2A nrlc37_1 634.356727679
Lrlc37 nrlc37_1 nrlc37_2 6.92305134218e-07
Crlc37 nrlc37_2 rlc7 1.05704749774e-12
* RLC[39] P2A-rlc9
Rrlc39 P2A nrlc39_1 339.035364771
Lrlc39 nrlc39_1 nrlc39_2 8.70460168495e-07
Crlc39 nrlc39_2 rlc9 1.19524969153e-12
* RLC[50] P3A-P3B
Rrlc50 P3A nrlc50_1 1294839.94051
Lrlc50 nrlc50_1 nrlc50_2 0.0550510863437
Crlc50 nrlc50_2 P3B 3.48891196436e-14
* RLC[54] P3A-rlc2
Rrlc54 P3A nrlc54_1 6921.95189827
Lrlc54 nrlc54_1 nrlc54_2 0.00174376490158
Crlc54 nrlc54_2 rlc2 4.04378697008e-14
* RLC[56] P3A-rlc4
Rrlc56 P3A nrlc56_1 44.6638274793
Lrlc56 nrlc56_1 nrlc56_2 1.93370169489e-06
Crlc56 nrlc56_2 rlc4 1.07704808731e-12
* RLC[57] P3A-rlc5
Rrlc57 P3A nrlc57_1 189405930227
Lrlc57 nrlc57_1 nrlc57_2 1.32072965268e-07
Crlc57 nrlc57_2 rlc5 2.06789119302e-09
* RLC[58] P3A-rlc6
Rrlc58 P3A nrlc58_1 14.0751060281
Lrlc58 nrlc58_1 nrlc58_2 5.77346024703e-07
Crlc58 nrlc58_2 rlc6 3.23810047414e-12
* RLC[62] P3A-rlc10
Rrlc62 P3A nrlc62_1 11127.3743233
Lrlc62 nrlc62_1 nrlc62_2 0.00313710276151
Crlc62 nrlc62_2 rlc10 2.81514545883e-14
* RLC[63] P3A-rlc11
Rrlc63 P3A nrlc63_1 1155.87529457
Lrlc63 nrlc63_1 nrlc63_2 1.39542687166e-13
Crlc63 nrlc63_2 rlc11 2.60508002062e-13
* RLC[64] P3A-rlc12
Rrlc64 P3A nrlc64_1 14252.5083603
Lrlc64 nrlc64_1 nrlc64_2 0.00515328380105
Crlc64 nrlc64_2 rlc12 2.81876546683e-14
* RLC[66] P3A-rlc14
Rrlc66 P3A nrlc66_1 401442.254342
Lrlc66 nrlc66_1 nrlc66_2 4.81735745856e-05
Crlc66 nrlc66_2 rlc14 3.48811556469e-13
* RLC[67] P3A-rlc15
Rrlc67 P3A nrlc67_1 2135.75436195
Lrlc67 nrlc67_1 nrlc67_2 0.000269231949813
Crlc67 nrlc67_2 rlc15 6.55815207175e-14
* RLC[68] P3A-P1B
Rrlc68 P3A nrlc68_1 394086530720
Lrlc68 nrlc68_1 nrlc68_2 6.98933461813e-07
Crlc68 nrlc68_2 P1B 5.93754873495e-10
* RLC[69] P4A-P1B
Rrlc69 P4A nrlc69_1 18.8102653209
Lrlc69 nrlc69_1 nrlc69_2 6.167950654e-07
Crlc69 nrlc69_2 P1B 1.9369059727e-12
* RLC[71] P4A-P3B
Rrlc71 P4A nrlc71_1 38794.8225018
Lrlc71 nrlc71_1 nrlc71_2 0.00036711795833
Crlc71 nrlc71_2 P3B 4.43948238037e-13
* RLC[75] P4A-rlc2
Rrlc75 P4A nrlc75_1 254.756325486
Lrlc75 nrlc75_1 nrlc75_2 8.83713453171e-07
Crlc75 nrlc75_2 rlc2 9.86363733716e-13
* RLC[77] P4A-rlc4
Rrlc77 P4A nrlc77_1 8291.15113827
Lrlc77 nrlc77_1 nrlc77_2 0.00187685443619
Crlc77 nrlc77_2 rlc4 3.03360071449e-14
* RLC[78] P4A-rlc5
Rrlc78 P4A nrlc78_1 52575.5100502
Lrlc78 nrlc78_1 nrlc78_2 0.0149200690645
Crlc78 nrlc78_2 rlc5 5.9973767935e-15
* RLC[80] P4A-rlc7
Rrlc80 P4A nrlc80_1 0.0283416284601
Lrlc80 nrlc80_1 nrlc80_2 6.88439587656e-12
Crlc80 nrlc80_2 rlc7 9.52299871039e-12
* RLC[82] P4A-rlc9
Rrlc82 P4A nrlc82_1 5134.96892362
Lrlc82 nrlc82_1 nrlc82_2 0.00072310481045
Crlc82 nrlc82_2 rlc9 3.04707470538e-14
* RLC[86] P4A-rlc13
Rrlc86 P4A nrlc86_1 3915229.80133
Lrlc86 nrlc86_1 nrlc86_2 0.442008358741
Crlc86 nrlc86_2 rlc13 1.99680264398e-13
* RLC[87] P4A-rlc14
Rrlc87 P4A nrlc87_1 1494.12370917
Lrlc87 nrlc87_1 nrlc87_2 6.53186098199e-09
Crlc87 nrlc87_2 rlc14 1.98791760615e-13
* RLC[89] P4A-P1B
Rrlc89 P4A nrlc89_1 6652.04666352
Lrlc89 nrlc89_1 nrlc89_2 6.49468306929e-05
Crlc89 nrlc89_2 P1B 4.39802927919e-13
* RLC[92] P1B-P4B
Rrlc92 P1B nrlc92_1 110.484867567
Lrlc92 nrlc92_1 nrlc92_2 4.10910136106e-12
Crlc92 nrlc92_2 P4B 1.35636081539e-11
* RLC[93] P1B-rlc0
Rrlc93 P1B nrlc93_1 0.0457280949815
Lrlc93 nrlc93_1 nrlc93_2 1.07426750635e-07
Crlc93 nrlc93_2 rlc0 0.000999835760318
* RLC[94] P1B-rlc1
Rrlc94 P1B nrlc94_1 7.55861327361
Lrlc94 nrlc94_1 nrlc94_2 8.75471257719e-07
Crlc94 nrlc94_2 rlc1 3.85428341199e-08
* RLC[95] P1B-rlc2
Rrlc95 P1B nrlc95_1 1.31792674763
Lrlc95 nrlc95_1 nrlc95_2 0.000870635725243
Crlc95 nrlc95_2 rlc2 0.001
* RLC[96] P1B-rlc3
Rrlc96 P1B nrlc96_1 0.682846962945
Lrlc96 nrlc96_1 nrlc96_2 2.77545904786e-09
Crlc96 nrlc96_2 rlc3 4.14424862952e-08
* RLC[100] P1B-rlc7
Rrlc100 P1B nrlc100_1 1604.78390796
Lrlc100 nrlc100_1 nrlc100_2 0.000101079762811
Crlc100 nrlc100_2 rlc7 1.64680485089e-11
* RLC[104] P1B-rlc11
Rrlc104 P1B nrlc104_1 0.106020921916
Lrlc104 nrlc104_1 nrlc104_2 4.52111811396e-06
Crlc104 nrlc104_2 rlc11 1.37677090512e-06
* RLC[106] P1B-rlc13
Rrlc106 P1B nrlc106_1 0.877068419683
Lrlc106 nrlc106_1 nrlc106_2 5.92528706315e-08
Crlc106 nrlc106_2 rlc13 8.55854500012e-11
* RLC[107] P1B-rlc14
Rrlc107 P1B nrlc107_1 43.0095323061
Lrlc107 nrlc107_1 nrlc107_2 1
Crlc107 nrlc107_2 rlc14 0.000202263508564
* RLC[110] P2B-P3B
Rrlc110 P2B nrlc110_1 235.676202391
Lrlc110 nrlc110_1 nrlc110_2 9.57997689802e-11
Crlc110 nrlc110_2 P3B 2.11273590404e-09
* RLC[115] P2B-rlc3
Rrlc115 P2B nrlc115_1 0.166372267202
Lrlc115 nrlc115_1 nrlc115_2 2.69015425383e-08
Crlc115 nrlc115_2 rlc3 0.001
* RLC[117] P2B-rlc5
Rrlc117 P2B nrlc117_1 3.19286672461
Lrlc117 nrlc117_1 nrlc117_2 2.04133378475e-08
Crlc117 nrlc117_2 rlc5 6.65082952461e-09
* RLC[118] P2B-rlc6
Rrlc118 P2B nrlc118_1 35.9570193325
Lrlc118 nrlc118_1 nrlc118_2 1.25743129019e-06
Crlc118 nrlc118_2 rlc6 1.02014883569e-10
* RLC[121] P2B-rlc9
Rrlc121 P2B nrlc121_1 2.63577435506
Lrlc121 nrlc121_1 nrlc121_2 1.48215160675e-07
Crlc121 nrlc121_2 rlc9 2.37046563337e-11
* RLC[123] P2B-rlc11
Rrlc123 P2B nrlc123_1 14.9745048475
Lrlc123 nrlc123_1 nrlc123_2 9.9624734656e-07
Crlc123 nrlc123_2 rlc11 6.70039262087e-11
* RLC[124] P2B-rlc12
Rrlc124 P2B nrlc124_1 98.6634308161
Lrlc124 nrlc124_1 nrlc124_2 1.70582847128e-06
Crlc124 nrlc124_2 rlc12 8.07402734297e-12
* RLC[125] P2B-rlc13
Rrlc125 P2B nrlc125_1 0.284068077796
Lrlc125 nrlc125_1 nrlc125_2 5.50596200098e-09
Crlc125 nrlc125_2 rlc13 0.001
* RLC[128] P2B-P1B
Rrlc128 P2B nrlc128_1 0.573431955234
Lrlc128 nrlc128_1 nrlc128_2 2.34789092162e-08
Crlc128 nrlc128_2 P1B 4.54233084097e-07
* RLC[129] P3B-P4B
Rrlc129 P3B nrlc129_1 0.156096693591
Lrlc129 nrlc129_1 nrlc129_2 3.66211355746e-07
Crlc129 nrlc129_2 P4B 7.14115467763e-05
* RLC[130] P3B-rlc0
Rrlc130 P3B nrlc130_1 0.0204574347606
Lrlc130 nrlc130_1 nrlc130_2 2.07510410344e-07
Crlc130 nrlc130_2 rlc0 7.13304737388e-05
* RLC[131] P3B-rlc1
Rrlc131 P3B nrlc131_1 0.230443615933
Lrlc131 nrlc131_1 nrlc131_2 4.92318586124e-08
Crlc131 nrlc131_2 rlc1 9.30714637176e-05
* RLC[132] P3B-rlc2
Rrlc132 P3B nrlc132_1 17.8539119272
Lrlc132 nrlc132_1 nrlc132_2 1.21522579843e-06
Crlc132 nrlc132_2 rlc2 1.63310900057e-10
* RLC[133] P3B-rlc3
Rrlc133 P3B nrlc133_1 12.1108056733
Lrlc133 nrlc133_1 nrlc133_2 3.00979971766e-06
Crlc133 nrlc133_2 rlc3 3.72244446731e-08
* RLC[138] P3B-rlc8
Rrlc138 P3B nrlc138_1 9.30250811093
Lrlc138 nrlc138_1 nrlc138_2 0.00185456087497
Crlc138 nrlc138_2 rlc8 0.001
* RLC[139] P3B-rlc9
Rrlc139 P3B nrlc139_1 8.78407525299
Lrlc139 nrlc139_1 nrlc139_2 7.52725099676e-08
Crlc139 nrlc139_2 rlc9 2.70842684494e-08
* RLC[140] P3B-rlc10
Rrlc140 P3B nrlc140_1 3.62750860702
Lrlc140 nrlc140_1 nrlc140_2 7.22210366378e-08
Crlc140 nrlc140_2 rlc10 2.42365182318e-10
* RLC[141] P3B-rlc11
Rrlc141 P3B nrlc141_1 0.853403099992
Lrlc141 nrlc141_1 nrlc141_2 8.4722487569e-08
Crlc141 nrlc141_2 rlc11 5.34783704583e-07
* RLC[142] P3B-rlc12
Rrlc142 P3B nrlc142_1 6.17599358159
Lrlc142 nrlc142_1 nrlc142_2 6.65586254878e-05
Crlc142 nrlc142_2 rlc12 0.000208172988455
* RLC[144] P3B-rlc14
Rrlc144 P3B nrlc144_1 27578.5398558
Lrlc144 nrlc144_1 nrlc144_2 0.00407075774075
Crlc144 nrlc144_2 rlc14 1.56353500691e-09
* RLC[147] P4B-rlc0
Rrlc147 P4B nrlc147_1 362.492689955
Lrlc147 nrlc147_1 nrlc147_2 7.01978502307e-06
Crlc147 nrlc147_2 rlc0 5.1995830393e-12
* RLC[148] P4B-rlc1
Rrlc148 P4B nrlc148_1 168.989390156
Lrlc148 nrlc148_1 nrlc148_2 4.66565948054e-06
Crlc148 nrlc148_2 rlc1 9.43245808772e-11
* RLC[151] P4B-rlc4
Rrlc151 P4B nrlc151_1 26.2421983175
Lrlc151 nrlc151_1 nrlc151_2 1.03269832123e-06
Crlc151 nrlc151_2 rlc4 1.26491339803e-09
* RLC[153] P4B-rlc6
Rrlc153 P4B nrlc153_1 101.645744023
Lrlc153 nrlc153_1 nrlc153_2 3.81492163549e-06
Crlc153 nrlc153_2 rlc6 1.7116101231e-08
* RLC[154] P4B-rlc7
Rrlc154 P4B nrlc154_1 1805.91241841
Lrlc154 nrlc154_1 nrlc154_2 3.09288223274e-07
Crlc154 nrlc154_2 rlc7 1.32115841265e-10
* RLC[155] P4B-rlc8
Rrlc155 P4B nrlc155_1 386.501524566
Lrlc155 nrlc155_1 nrlc155_2 2.1196122608e-05
Crlc155 nrlc155_2 rlc8 2.91812169581e-11
* RLC[157] P4B-rlc10
Rrlc157 P4B nrlc157_1 256.975778183
Lrlc157 nrlc157_1 nrlc157_2 3.43831441055e-06
Crlc157 nrlc157_2 rlc10 3.06904191709e-11
* RLC[161] P4B-rlc14
Rrlc161 P4B nrlc161_1 560.164842232
Lrlc161 nrlc161_1 nrlc161_2 8.88214798463e-06
Crlc161 nrlc161_2 rlc14 3.86267364731e-11
* RLC[163] P4B-P1B
Rrlc163 P4B nrlc163_1 0.611406881402
Lrlc163 nrlc163_1 nrlc163_2 1.58784199256e-07
Crlc163 nrlc163_2 P1B 2.73919891739e-06
* RLC[170] rlc0-rlc7
Rrlc170 rlc0 nrlc170_1 1564.64796418
Lrlc170 nrlc170_1 nrlc170_2 8.99442462319e-05
Crlc170 nrlc170_2 rlc7 9.86504082079e-12
* RLC[171] rlc0-rlc8
Rrlc171 rlc0 nrlc171_1 0.747147920392
Lrlc171 nrlc171_1 nrlc171_2 0.0001644503587
Crlc171 nrlc171_2 rlc8 0.00037057546151
* RLC[172] rlc0-rlc9
Rrlc172 rlc0 nrlc172_1 28.03548796
Lrlc172 nrlc172_1 nrlc172_2 1.14992144219e-06
Crlc172 nrlc172_2 rlc9 4.11776069187e-11
* RLC[174] rlc0-rlc11
Rrlc174 rlc0 nrlc174_1 2.50275726148
Lrlc174 nrlc174_1 nrlc174_2 1.64576852819e-09
Crlc174 nrlc174_2 rlc11 2.15170815002e-07
* RLC[178] rlc0-rlc15
Rrlc178 rlc0 nrlc178_1 1.59148922589
Lrlc178 nrlc178_1 nrlc178_2 1.70556183371e-05
Crlc178 nrlc178_2 rlc15 5.96823770113e-06
* RLC[179] rlc0-P1B
Rrlc179 rlc0 nrlc179_1 4.04602516873
Lrlc179 nrlc179_1 nrlc179_2 2.58598174076e-07
Crlc179 nrlc179_2 P1B 1.82673963454e-08
* RLC[181] rlc1-rlc3
Rrlc181 rlc1 nrlc181_1 6.12393663815
Lrlc181 nrlc181_1 nrlc181_2 1.72750952228e-07
Crlc181 nrlc181_2 rlc3 3.73542143676e-09
* RLC[182] rlc1-rlc4
Rrlc182 rlc1 nrlc182_1 2.26549569012
Lrlc182 nrlc182_1 nrlc182_2 2.09843734048e-07
Crlc182 nrlc182_2 rlc4 8.13883171075e-10
* RLC[184] rlc1-rlc6
Rrlc184 rlc1 nrlc184_1 139.978730493
Lrlc184 nrlc184_1 nrlc184_2 2.9233921456e-06
Crlc184 nrlc184_2 rlc6 1.9103861692e-08
* RLC[185] rlc1-rlc7
Rrlc185 rlc1 nrlc185_1 30.1796840648
Lrlc185 nrlc185_1 nrlc185_2 6.13918741278e-06
Crlc185 nrlc185_2 rlc7 7.48926165328e-12
* RLC[186] rlc1-rlc8
Rrlc186 rlc1 nrlc186_1 2.47345258656
Lrlc186 nrlc186_1 nrlc186_2 1.78406199086e-07
Crlc186 nrlc186_2 rlc8 6.12011143179e-09
* RLC[189] rlc1-rlc11
Rrlc189 rlc1 nrlc189_1 33.2918300108
Lrlc189 nrlc189_1 nrlc189_2 0.00169394427852
Crlc189 nrlc189_2 rlc11 0.000613195344889
* RLC[190] rlc1-rlc12
Rrlc190 rlc1 nrlc190_1 0.0110901688733
Lrlc190 nrlc190_1 nrlc190_2 5.49851275568e-11
Crlc190 nrlc190_2 rlc12 0.000537831100988
* RLC[197] rlc2-rlc5
Rrlc197 rlc2 nrlc197_1 1.00139011903
Lrlc197 nrlc197_1 nrlc197_2 1.5960898234e-06
Crlc197 nrlc197_2 rlc5 0.001
* RLC[198] rlc2-rlc6
Rrlc198 rlc2 nrlc198_1 0.758177757893
Lrlc198 nrlc198_1 nrlc198_2 1.85262345525e-07
Crlc198 nrlc198_2 rlc6 3.58320490838e-10
* RLC[199] rlc2-rlc7
Rrlc199 rlc2 nrlc199_1 188302.621364
Lrlc199 nrlc199_1 nrlc199_2 0.374823503169
Crlc199 nrlc199_2 rlc7 8.08486929412e-11
* RLC[200] rlc2-rlc8
Rrlc200 rlc2 nrlc200_1 0.131070992696
Lrlc200 nrlc200_1 nrlc200_2 2.98253560302e-08
Crlc200 nrlc200_2 rlc8 1.9457007513e-09
* RLC[201] rlc2-rlc9
Rrlc201 rlc2 nrlc201_1 91.4050081074
Lrlc201 nrlc201_1 nrlc201_2 6.2812260139e-06
Crlc201 nrlc201_2 rlc9 4.268354438e-11
* RLC[203] rlc2-rlc11
Rrlc203 rlc2 nrlc203_1 0.665105450593
Lrlc203 nrlc203_1 nrlc203_2 8.63086368504e-09
Crlc203 nrlc203_2 rlc11 2.34325045791e-06
* RLC[204] rlc2-rlc12
Rrlc204 rlc2 nrlc204_1 6.72550761989
Lrlc204 nrlc204_1 nrlc204_2 1.03987079662e-13
Crlc204 nrlc204_2 rlc12 4.1341930304e-08
* RLC[207] rlc2-rlc15
Rrlc207 rlc2 nrlc207_1 15.7270892522
Lrlc207 nrlc207_1 nrlc207_2 1.19389322814e-06
Crlc207 nrlc207_2 rlc15 1.64728720282e-10
* RLC[210] rlc3-rlc5
Rrlc210 rlc3 nrlc210_1 0.761283788861
Lrlc210 nrlc210_1 nrlc210_2 1.67307051868e-05
Crlc210 nrlc210_2 rlc5 0.001
* RLC[212] rlc3-rlc7
Rrlc212 rlc3 nrlc212_1 1389.12243107
Lrlc212 nrlc212_1 nrlc212_2 7.22303461631e-05
Crlc212 nrlc212_2 rlc7 4.79800831664e-11
* RLC[213] rlc3-rlc8
Rrlc213 rlc3 nrlc213_1 2.17558131074
Lrlc213 nrlc213_1 nrlc213_2 8.65813960954e-08
Crlc213 nrlc213_2 rlc8 1.54337493225e-09
* RLC[214] rlc3-rlc9
Rrlc214 rlc3 nrlc214_1 128.688636289
Lrlc214 nrlc214_1 nrlc214_2 2.77188152153e-11
Crlc214 nrlc214_2 rlc9 3.38265364233e-09
* RLC[216] rlc3-rlc11
Rrlc216 rlc3 nrlc216_1 0.941410450307
Lrlc216 nrlc216_1 nrlc216_2 3.02872889163e-08
Crlc216 nrlc216_2 rlc11 3.07068832747e-08
* RLC[218] rlc3-rlc13
Rrlc218 rlc3 nrlc218_1 1.03073023613
Lrlc218 nrlc218_1 nrlc218_2 7.94360843905e-07
Crlc218 nrlc218_2 rlc13 0.001
* RLC[220] rlc3-rlc15
Rrlc220 rlc3 nrlc220_1 0.209919911763
Lrlc220 nrlc220_1 nrlc220_2 3.88473219625e-08
Crlc220 nrlc220_2 rlc15 3.17997281166e-07
* RLC[221] rlc3-P1B
Rrlc221 rlc3 nrlc221_1 0.022918593441
Lrlc221 nrlc221_1 nrlc221_2 4.99229194973e-09
Crlc221 nrlc221_2 P1B 6.30102630514e-06
* RLC[225] rlc4-rlc8
Rrlc225 rlc4 nrlc225_1 52.7075707681
Lrlc225 nrlc225_1 nrlc225_2 1.99669782583e-07
Crlc225 nrlc225_2 rlc8 5.05241450361e-10
* RLC[226] rlc4-rlc9
Rrlc226 rlc4 nrlc226_1 26.3337189894
Lrlc226 nrlc226_1 nrlc226_2 5.2702408643e-07
Crlc226 nrlc226_2 rlc9 6.6504388739e-11
* RLC[229] rlc4-rlc12
Rrlc229 rlc4 nrlc229_1 6.96305833743
Lrlc229 nrlc229_1 nrlc229_2 1.71481105218e-07
Crlc229 nrlc229_2 rlc12 0.000487121904501
* RLC[231] rlc4-rlc14
Rrlc231 rlc4 nrlc231_1 21885.3884645
Lrlc231 nrlc231_1 nrlc231_2 0.969015787967
Crlc231 nrlc231_2 rlc14 2.13027880574e-08
* RLC[233] rlc4-P1B
Rrlc233 rlc4 nrlc233_1 0.0309174426764
Lrlc233 nrlc233_1 nrlc233_2 0.000601019633368
Crlc233 nrlc233_2 P1B 0.001
* RLC[234] rlc5-rlc6
Rrlc234 rlc5 nrlc234_1 0.690788818161
Lrlc234 nrlc234_1 nrlc234_2 6.88032261033e-05
Crlc234 nrlc234_2 rlc6 0.001
* RLC[236] rlc5-rlc8
Rrlc236 rlc5 nrlc236_1 0.827998603274
Lrlc236 nrlc236_1 nrlc236_2 6.53644039059e-08
Crlc236 nrlc236_2 rlc8 1.07067757012e-09
* RLC[240] rlc5-rlc12
Rrlc240 rlc5 nrlc240_1 0.472765822028
Lrlc240 nrlc240_1 nrlc240_2 1.46795375971e-09
Crlc240 nrlc240_2 rlc12 1.50841553599e-06
* RLC[243] rlc5-rlc15
Rrlc243 rlc5 nrlc243_1 0.450717192573
Lrlc243 nrlc243_1 nrlc243_2 2.06595461592e-08
Crlc243 nrlc243_2 rlc15 1.76667729363e-06
* RLC[244] rlc5-P1B
Rrlc244 rlc5 nrlc244_1 0.17213906297
Lrlc244 nrlc244_1 nrlc244_2 7.74421867782e-08
Crlc244 nrlc244_2 P1B 0.000832592511897
* RLC[245] rlc6-rlc7
Rrlc245 rlc6 nrlc245_1 2.64612950536
Lrlc245 nrlc245_1 nrlc245_2 4.49181266245e-07
Crlc245 nrlc245_2 rlc7 7.127823464e-11
* RLC[246] rlc6-rlc8
Rrlc246 rlc6 nrlc246_1 2.04469821871
Lrlc246 nrlc246_1 nrlc246_2 4.6729599876e-07
Crlc246 nrlc246_2 rlc8 1.2419128355e-10
* RLC[248] rlc6-rlc10
Rrlc248 rlc6 nrlc248_1 0.718578359283
Lrlc248 nrlc248_1 nrlc248_2 4.20933382269e-07
Crlc248 nrlc248_2 rlc10 9.42068744746e-10
* RLC[253] rlc6-rlc15
Rrlc253 rlc6 nrlc253_1 0.216302854879
Lrlc253 nrlc253_1 nrlc253_2 4.92552130672e-08
Crlc253 nrlc253_2 rlc15 1.17036150844e-09
* RLC[254] rlc6-P1B
Rrlc254 rlc6 nrlc254_1 0.0366024391345
Lrlc254 nrlc254_1 nrlc254_2 6.58132904408e-05
Crlc254 nrlc254_2 P1B 0.001
* RLC[255] rlc7-rlc8
Rrlc255 rlc7 nrlc255_1 5.33712019235
Lrlc255 nrlc255_1 nrlc255_2 1.12650643869e-06
Crlc255 nrlc255_2 rlc8 4.83825082223e-11
* RLC[258] rlc7-rlc11
Rrlc258 rlc7 nrlc258_1 0.670109055258
Lrlc258 nrlc258_1 nrlc258_2 1.63843229478e-07
Crlc258 nrlc258_2 rlc11 4.05416420874e-10
* RLC[259] rlc7-rlc12
Rrlc259 rlc7 nrlc259_1 41557.2998224
Lrlc259 nrlc259_1 nrlc259_2 0.00997841933544
Crlc259 nrlc259_2 rlc12 2.0903824615e-11
* RLC[260] rlc7-rlc13
Rrlc260 rlc7 nrlc260_1 6808481272.44
Lrlc260 nrlc260_1 nrlc260_2 0.916381937646
Crlc260 nrlc260_2 rlc13 2.01489115363e-05
* RLC[261] rlc7-rlc14
Rrlc261 rlc7 nrlc261_1 1134.71198167
Lrlc261 nrlc261_1 nrlc261_2 1.7938290924e-06
Crlc261 nrlc261_2 rlc14 1.60214885859e-11
* RLC[262] rlc7-rlc15
Rrlc262 rlc7 nrlc262_1 4135.48513819
Lrlc262 nrlc262_1 nrlc262_2 0.00103137955777
Crlc262 nrlc262_2 rlc15 1.20745487287e-09
* RLC[263] rlc7-P1B
Rrlc263 rlc7 nrlc263_1 88339.0373605
Lrlc263 nrlc263_1 nrlc263_2 0.278920095581
Crlc263 nrlc263_2 P1B 4.07033344647e-10
* RLC[267] rlc8-rlc12
Rrlc267 rlc8 nrlc267_1 0.776669160556
Lrlc267 nrlc267_1 nrlc267_2 6.09213419871e-09
Crlc267 nrlc267_2 rlc12 4.47561662802e-08
* RLC[268] rlc8-rlc13
Rrlc268 rlc8 nrlc268_1 8.29637708717
Lrlc268 nrlc268_1 nrlc268_2 7.26436264127e-08
Crlc268 nrlc268_2 rlc13 3.08547730051e-06
* RLC[272] rlc9-rlc10
Rrlc272 rlc9 nrlc272_1 10.9919763283
Lrlc272 nrlc272_1 nrlc272_2 9.2293979448e-10
Crlc272 nrlc272_2 rlc10 6.54027859791e-10
* RLC[273] rlc9-rlc11
Rrlc273 rlc9 nrlc273_1 0.184709637463
Lrlc273 nrlc273_1 nrlc273_2 2.50737227194e-07
Crlc273 nrlc273_2 rlc11 1.27592250621e-05
* RLC[274] rlc9-rlc12
Rrlc274 rlc9 nrlc274_1 9.35498194007
Lrlc274 nrlc274_1 nrlc274_2 2.57142392974e-07
Crlc274 nrlc274_2 rlc12 7.18901676552e-10
* RLC[275] rlc9-rlc13
Rrlc275 rlc9 nrlc275_1 53.7068893083
Lrlc275 nrlc275_1 nrlc275_2 1.02829744397e-06
Crlc275 nrlc275_2 rlc13 4.94450047123e-11
* RLC[285] rlc11-rlc12
Rrlc285 rlc11 nrlc285_1 4.16909982845
Lrlc285 nrlc285_1 nrlc285_2 1.61646483128e-07
Crlc285 nrlc285_2 rlc12 6.62360875814e-10
* RLC[286] rlc11-rlc13
Rrlc286 rlc11 nrlc286_1 8.51892589699
Lrlc286 nrlc286_1 nrlc286_2 1.99945995706e-07
Crlc286 nrlc286_2 rlc13 2.28597395477e-09
* RLC[288] rlc11-rlc15
Rrlc288 rlc11 nrlc288_1 2.9516646882
Lrlc288 nrlc288_1 nrlc288_2 1.13308554988e-07
Crlc288 nrlc288_2 rlc15 4.03487359737e-10
* RLC[289] rlc11-P1B
Rrlc289 rlc11 nrlc289_1 9.72342331756
Lrlc289 nrlc289_1 nrlc289_2 4.17745616737e-07
Crlc289 nrlc289_2 P1B 1.85893098197e-10
* RLC[290] rlc12-rlc13
Rrlc290 rlc12 nrlc290_1 3.72830240143
Lrlc290 nrlc290_1 nrlc290_2 2.31326626276e-08
Crlc290 nrlc290_2 rlc13 1.86209533553e-07
* RLC[295] rlc13-rlc15
Rrlc295 rlc13 nrlc295_1 113.375194738
Lrlc295 nrlc295_1 nrlc295_2 4.13110483744e-06
Crlc295 nrlc295_2 rlc15 4.40991737671e-12
* RLC[297] rlc14-rlc15
Rrlc297 rlc14 nrlc297_1 161.480645765
Lrlc297 nrlc297_1 nrlc297_2 1.73776590899e-06
Crlc297 nrlc297_2 rlc15 2.81979060804e-11
* DC[0] P1A-P2A
Rdc0 P1A ndc0_1 0.0249917497459
Ldc0 ndc0_1 P2A 9.12931439382e-08
* DC[23] P3A-P4A
Rdc23 P3A ndc23_1 0.118251677546
Ldc23 ndc23_1 P4A 9.29591437008e-08
* DC[42] P1B-P2B
Rdc42 P1B ndc42_1 0.0724992179469
Ldc42 ndc42_1 P2B 7.06643362486e-08
* DC[43] P1B-P3B
Rdc43 P1B ndc43_1 290.111790557
Ldc43 ndc43_1 P3B 0.00037178204141
* DC[46] P1B-dc1
Rdc46 P1B ndc46_1 10.6682032436
Ldc46 ndc46_1 dc1 1.71469395621e-05
* DC[47] P1B-dc2
Rdc47 P1B ndc47_1 0.0475111555689
Ldc47 ndc47_1 dc2 1.22857621361e-07
* DC[48] P1B-dc3
Rdc48 P1B ndc48_1 0.0100064809679
Ldc48 ndc48_1 dc3 1.89892956802e-07
* DC[50] P2B-P3B
Rdc50 P2B ndc50_1 198.72840672
Ldc50 ndc50_1 P3B 3.16458026567e-05
* DC[51] P2B-P4B
Rdc51 P2B ndc51_1 1209.09270988
Ldc51 ndc51_1 P4B 0.00110048097039
* DC[52] P2B-dc0
Rdc52 P2B ndc52_1 0.381900439321
Ldc52 ndc52_1 dc0 2.07481156278e-07
* DC[55] P2B-dc3
Rdc55 P2B ndc55_1 10.6867415626
Ldc55 ndc55_1 dc3 4.51992138359e-06
* DC[57] P3B-P4B
Rdc57 P3B ndc57_1 0.012803274781
Ldc57 ndc57_1 P4B 1.13049609211e-07
* DC[58] P3B-dc0
Rdc58 P3B ndc58_1 120.004169454
Ldc58 ndc58_1 dc0 1.91132137148e-05
* DC[59] P3B-dc1
Rdc59 P3B ndc59_1 0.122524915241
Ldc59 ndc59_1 dc1 5.91506985314e-08
* DC[62] P3B-P1B
Rdc62 P3B ndc62_1 10.0287591978
Ldc62 ndc62_1 P1B 1.28504806648e-05
* DC[63] P4B-dc0
Rdc63 P4B ndc63_1 0.11816436163
Ldc63 ndc63_1 dc0 1.12874774348e-06
* DC[64] P4B-dc1
Rdc64 P4B ndc64_1 0.0100108239725
Ldc64 ndc64_1 dc1 5.94626353815e-06
* DC[69] dc0-dc2
Rdc69 dc0 ndc69_1 0.01
Ldc69 ndc69_1 dc2 9.12809012062e-05
* DC[70] dc0-dc3
Rdc70 dc0 ndc70_1 0.0100056089068
Ldc70 ndc70_1 dc3 0.000255639664168
* DC[72] dc1-dc2
Rdc72 dc1 ndc72_1 0.123191715143
Ldc72 ndc72_1 dc2 2.19069134087e-07
* DC[74] dc1-P1B
Rdc74 dc1 ndc74_1 10.0944821035
Ldc74 ndc74_1 P1B 1.62247969392e-05
* DC[76] dc2-P1B
Rdc76 dc2 ndc76_1 0.0585777075492
Ldc76 ndc76_1 P1B 1.51474321341e-07
* DC[77] dc3-P1B
Rdc77 dc3 ndc77_1 0.0100064808814
Ldc77 ndc77_1 P1B 1.89682094518e-07
* ---- leaks
Rleak_P1A P1A P1B 1e+12
Rleak_P2A P2A P1B 1e+12
Rleak_P2B P2B P1B 1e+12
Rleak_P3A P3A P1B 1e+12
Rleak_P3B P3B P1B 1e+12
Rleak_P4A P4A P1B 1e+12
Rleak_P4B P4B P1B 1e+12
Rleak_dc0 dc0 P1B 1e+12
Rleak_dc1 dc1 P1B 1e+12
Rleak_dc2 dc2 P1B 1e+12
Rleak_dc3 dc3 P1B 1e+12
Rleak_rlc0 rlc0 P1B 1e+12
Rleak_rlc1 rlc1 P1B 1e+12
Rleak_rlc10 rlc10 P1B 1e+12
Rleak_rlc11 rlc11 P1B 1e+12
Rleak_rlc12 rlc12 P1B 1e+12
Rleak_rlc13 rlc13 P1B 1e+12
Rleak_rlc14 rlc14 P1B 1e+12
Rleak_rlc15 rlc15 P1B 1e+12
Rleak_rlc2 rlc2 P1B 1e+12
Rleak_rlc3 rlc3 P1B 1e+12
Rleak_rlc4 rlc4 P1B 1e+12
Rleak_rlc5 rlc5 P1B 1e+12
Rleak_rlc6 rlc6 P1B 1e+12
Rleak_rlc7 rlc7 P1B 1e+12
Rleak_rlc8 rlc8 P1B 1e+12
Rleak_rlc9 rlc9 P1B 1e+12
.ends fitted
