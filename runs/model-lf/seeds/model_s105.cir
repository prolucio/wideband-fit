* fitted: 4-port fitted model, reference z0 = 50 Ohm
* port p is PpA (+) to PpB (-); the reference node is P1B
.subckt fitted P1A P1B P2A P2B P3A P3B P4A P4B
* ---- branches
* RLC[2] P1A-P4A
Rrlc2 P1A nrlc2_1 447536372066
Lrlc2 nrlc2_1 nrlc2_2 2.15729905465e-05
Crlc2 nrlc2_2 P4A 1.80899728373e-16
* RLC[3] P1A-P1B
Rrlc3 P1A nrlc3_1 1493.71971629
Lrlc3 nrlc3_1 nrlc3_2 6.05949571236e-05
Crlc3 nrlc3_2 P1B 3.01755883201e-14
* RLC[7] P1A-rlc0
Rrlc7 P1A nrlc7_1 14846.517337
Lrlc7 nrlc7_1 nrlc7_2 0.00529546647115
Crlc7 nrlc7_2 rlc0 2.66939310049e-14
* RLC[8] P1A-rlc1
Rrlc8 P1A nrlc8_1 14720.7559243
Lrlc8 nrlc8_1 nrlc8_2 0.00468220461898
Crlc8 nrlc8_2 rlc1 2.40075396961e-14
* RLC[10] P1A-rlc3
Rrlc10 P1A nrlc10_1 560415.486112
Lrlc10 nrlc10_1 nrlc10_2 0.000113437940904
Crlc10 nrlc10_2 rlc3 2.72994756089e-13
* RLC[11] P1A-rlc4
Rrlc11 P1A nrlc11_1 1745.60030737
Lrlc11 nrlc11_1 nrlc11_2 4.56219432563e-13
Crlc11 nrlc11_2 rlc4 1.9064152946e-13
* RLC[12] P1A-rlc5
Rrlc12 P1A nrlc12_1 24.8087369359
Lrlc12 nrlc12_1 nrlc12_2 9.69468747002e-07
Crlc12 nrlc12_2 rlc5 1.75017709464e-12
* RLC[13] P1A-rlc6
Rrlc13 P1A nrlc13_1 28.7557138554
Lrlc13 nrlc13_1 nrlc13_2 1.10322320803e-06
Crlc13 nrlc13_2 rlc6 1.48242446329e-12
* RLC[14] P1A-rlc7
Rrlc14 P1A nrlc14_1 5584.48970306
Lrlc14 nrlc14_1 nrlc14_2 0.000621128612816
Crlc14 nrlc14_2 rlc7 2.21295222131e-14
* RLC[15] P1A-rlc8
Rrlc15 P1A nrlc15_1 654861812206
Lrlc15 nrlc15_1 nrlc15_2 0.968429134548
Crlc15 nrlc15_2 rlc8 7.64847232663e-09
* RLC[16] P1A-rlc9
Rrlc16 P1A nrlc16_1 397.069642366
Lrlc16 nrlc16_1 nrlc16_2 6.12316030344e-07
Crlc16 nrlc16_2 rlc9 1.5964611081e-12
* RLC[19] P1A-rlc12
Rrlc19 P1A nrlc19_1 11493.9895384
Lrlc19 nrlc19_1 nrlc19_2 0.0026487175181
Crlc19 nrlc19_2 rlc12 2.22767350425e-14
* RLC[24] P2A-P3A
Rrlc24 P2A nrlc24_1 5885.65213248
Lrlc24 nrlc24_1 nrlc24_2 2.71843362349e-05
Crlc24 nrlc24_2 P3A 3.42104702817e-14
* RLC[26] P2A-P1B
Rrlc26 P2A nrlc26_1 9.85847880716
Lrlc26 nrlc26_1 nrlc26_2 4.34934988174e-07
Crlc26 nrlc26_2 P1B 4.97235379234e-12
* RLC[34] P2A-rlc4
Rrlc34 P2A nrlc34_1 6042001.94879
Lrlc34 nrlc34_1 nrlc34_2 0.0363904756986
Crlc34 nrlc34_2 rlc4 1.91373997782e-13
* RLC[35] P2A-rlc5
Rrlc35 P2A nrlc35_1 6000.0384653
Lrlc35 nrlc35_1 nrlc35_2 7.14635054565e-05
Crlc35 nrlc35_2 rlc5 3.25751638673e-13
* RLC[36] P2A-rlc6
Rrlc36 P2A nrlc36_1 338234851353
Lrlc36 nrlc36_1 nrlc36_2 0.971851044526
Crlc36 nrlc36_2 rlc6 2.1049400222e-08
* RLC[37] P2A-rlc7
Rrlc37 P2A nrlc37_1 69893.1443008
Lrlc37 nrlc37_1 nrlc37_2 0.000784389739792
Crlc37 nrlc37_2 rlc7 3.03426682655e-13
* RLC[40] P2A-rlc10
Rrlc40 P2A nrlc40_1 51.6659023508
Lrlc40 nrlc40_1 nrlc40_2 2.21663864394e-06
Crlc40 nrlc40_2 rlc10 9.2266565153e-13
* RLC[42] P2A-rlc12
Rrlc42 P2A nrlc42_1 10039.2266416
Lrlc42 nrlc42_1 nrlc42_2 0.00250772967546
Crlc42 nrlc42_2 rlc12 2.76463430205e-14
* RLC[43] P2A-rlc13
Rrlc43 P2A nrlc43_1 281903818936
Lrlc43 nrlc43_1 nrlc43_2 0.00583529733478
Crlc43 nrlc43_2 rlc13 2.96132768238e-08
* RLC[44] P2A-rlc14
Rrlc44 P2A nrlc44_1 318559354554
Lrlc44 nrlc44_1 nrlc44_2 0.981683704578
Crlc44 nrlc44_2 rlc14 2.85658602566e-08
* RLC[46] P2A-P1B
Rrlc46 P2A nrlc46_1 11357.2215202
Lrlc46 nrlc46_1 nrlc46_2 0.0032220848008
Crlc46 nrlc46_2 P1B 2.7755577211e-14
* RLC[48] P3A-P1B
Rrlc48 P3A nrlc48_1 4176.83632975
Lrlc48 nrlc48_1 nrlc48_2 0.000668460544237
Crlc48 nrlc48_2 P1B 4.25734017836e-14
* RLC[49] P3A-P2B
Rrlc49 P3A nrlc49_1 342081198473
Lrlc49 nrlc49_1 nrlc49_2 7.78444979672e-07
Crlc49 nrlc49_2 P2B 1.49261228053e-09
* RLC[54] P3A-rlc2
Rrlc54 P3A nrlc54_1 3164.35625814
Lrlc54 nrlc54_1 nrlc54_2 0.000636217607042
Crlc54 nrlc54_2 rlc2 7.05980051197e-14
* RLC[55] P3A-rlc3
Rrlc55 P3A nrlc55_1 4968.72266939
Lrlc55 nrlc55_1 nrlc55_2 0.000617286796317
Crlc55 nrlc55_2 rlc3 2.77814534954e-14
* RLC[57] P3A-rlc5
Rrlc57 P3A nrlc57_1 34.8638408358
Lrlc57 nrlc57_1 nrlc57_2 6.510473656e-07
Crlc57 nrlc57_2 rlc5 1.60572826322e-12
* RLC[60] P3A-rlc8
Rrlc60 P3A nrlc60_1 12277.2561412
Lrlc60 nrlc60_1 nrlc60_2 0.00390289188643
Crlc60 nrlc60_2 rlc8 2.87701004596e-14
* RLC[61] P3A-rlc9
Rrlc61 P3A nrlc61_1 0.189804883171
Lrlc61 nrlc61_1 nrlc61_2 4.82717612097e-10
Crlc61 nrlc61_2 rlc9 1.48879832701e-11
* RLC[62] P3A-rlc10
Rrlc62 P3A nrlc62_1 19398.2874038
Lrlc62 nrlc62_1 nrlc62_2 0.00776910386317
Crlc62 nrlc62_2 rlc10 2.2940434481e-14
* RLC[65] P3A-rlc13
Rrlc65 P3A nrlc65_1 3909.29224474
Lrlc65 nrlc65_1 nrlc65_2 0.000699266969292
Crlc65 nrlc65_2 rlc13 5.08398463058e-14
* RLC[70] P4A-P2B
Rrlc70 P4A nrlc70_1 3551204.84499
Lrlc70 nrlc70_1 nrlc70_2 0.0546646008085
Crlc70 nrlc70_2 P2B 3.06434140185e-13
* RLC[73] P4A-rlc0
Rrlc73 P4A nrlc73_1 990.972636905
Lrlc73 nrlc73_1 nrlc73_2 2.36369932465e-11
Crlc73 nrlc73_2 rlc0 2.0026719325e-13
* RLC[78] P4A-rlc5
Rrlc78 P4A nrlc78_1 45078.7258283
Lrlc78 nrlc78_1 nrlc78_2 0.000358458041317
Crlc78 nrlc78_2 rlc5 4.7566944208e-13
* RLC[79] P4A-rlc6
Rrlc79 P4A nrlc79_1 211756801533
Lrlc79 nrlc79_1 nrlc79_2 1.18210758923e-06
Crlc79 nrlc79_2 rlc6 2.8313348727e-09
* RLC[81] P4A-rlc8
Rrlc81 P4A nrlc81_1 10378.9676073
Lrlc81 nrlc81_1 nrlc81_2 0.00296611443913
Crlc81 nrlc81_2 rlc8 3.05940576385e-14
* RLC[82] P4A-rlc9
Rrlc82 P4A nrlc82_1 406690.523478
Lrlc82 nrlc82_1 nrlc82_2 0.00241588496403
Crlc82 nrlc82_2 rlc9 3.71845736141e-13
* RLC[85] P4A-rlc12
Rrlc85 P4A nrlc85_1 9958.3619551
Lrlc85 nrlc85_1 nrlc85_2 0.00251392882234
Crlc85 nrlc85_2 rlc12 2.81666146917e-14
* RLC[88] P4A-rlc15
Rrlc88 P4A nrlc88_1 510.897419895
Lrlc88 nrlc88_1 nrlc88_2 2.34151579199e-06
Crlc88 nrlc88_2 rlc15 5.68366141813e-13
* RLC[89] P4A-P1B
Rrlc89 P4A nrlc89_1 8604.23089304
Lrlc89 nrlc89_1 nrlc89_2 9.60046481369e-05
Crlc89 nrlc89_2 P1B 1.59772601291e-13
* RLC[90] P1B-P2B
Rrlc90 P1B nrlc90_1 0.503772654242
Lrlc90 nrlc90_1 nrlc90_2 6.8782969811e-07
Crlc90 nrlc90_2 P2B 0.001
* RLC[92] P1B-P4B
Rrlc92 P1B nrlc92_1 37.0426883773
Lrlc92 nrlc92_1 nrlc92_2 3.61618928951e-06
Crlc92 nrlc92_2 P4B 1.28909431072e-10
* RLC[93] P1B-rlc0
Rrlc93 P1B nrlc93_1 1.05261559037
Lrlc93 nrlc93_1 nrlc93_2 9.04828500158e-07
Crlc93 nrlc93_2 rlc0 4.39150621646e-05
* RLC[96] P1B-rlc3
Rrlc96 P1B nrlc96_1 0.870816894465
Lrlc96 nrlc96_1 nrlc96_2 1.10730999609e-07
Crlc96 nrlc96_2 rlc3 4.72540878936e-08
* RLC[97] P1B-rlc4
Rrlc97 P1B nrlc97_1 43.4493850182
Lrlc97 nrlc97_1 nrlc97_2 1.84641299529e-06
Crlc97 nrlc97_2 rlc4 2.26145425698e-11
* RLC[98] P1B-rlc5
Rrlc98 P1B nrlc98_1 1.98611725888
Lrlc98 nrlc98_1 nrlc98_2 1.06246371377e-06
Crlc98 nrlc98_2 rlc5 4.91545845546e-06
* RLC[100] P1B-rlc7
Rrlc100 P1B nrlc100_1 5.68145342187
Lrlc100 nrlc100_1 nrlc100_2 2.0584509571e-06
Crlc100 nrlc100_2 rlc7 3.73336754012e-07
* RLC[101] P1B-rlc8
Rrlc101 P1B nrlc101_1 8.32188352313
Lrlc101 nrlc101_1 nrlc101_2 2.57553080617e-06
Crlc101 nrlc101_2 rlc8 2.99328230677e-08
* RLC[102] P1B-rlc9
Rrlc102 P1B nrlc102_1 21.710449175
Lrlc102 nrlc102_1 nrlc102_2 7.8242988502e-06
Crlc102 nrlc102_2 rlc9 1.84444327382e-11
* RLC[103] P1B-rlc10
Rrlc103 P1B nrlc103_1 41.8600294865
Lrlc103 nrlc103_1 nrlc103_2 5.28645131969e-06
Crlc103 nrlc103_2 rlc10 5.60439004886e-12
* RLC[105] P1B-rlc12
Rrlc105 P1B nrlc105_1 5.51673189184
Lrlc105 nrlc105_1 nrlc105_2 2.07277829478e-06
Crlc105 nrlc105_2 rlc12 7.57238024284e-11
* RLC[108] P1B-rlc15
Rrlc108 P1B nrlc108_1 280.191482104
Lrlc108 nrlc108_1 nrlc108_2 1.54423573316e-08
Crlc108 nrlc108_2 rlc15 4.36468321686e-09
* RLC[110] P2B-P3B
Rrlc110 P2B nrlc110_1 122.338320895
Lrlc110 nrlc110_1 nrlc110_2 1.33935178679e-06
Crlc110 nrlc110_2 P3B 2.92951931692e-09
* RLC[111] P2B-P4B
Rrlc111 P2B nrlc111_1 0.384179071543
Lrlc111 nrlc111_1 nrlc111_2 5.6964410026e-05
Crlc111 nrlc111_2 P4B 0.000703828306797
* RLC[112] P2B-rlc0
Rrlc112 P2B nrlc112_1 0.486394825196
Lrlc112 nrlc112_1 nrlc112_2 4.07742974303e-08
Crlc112 nrlc112_2 rlc0 0.000250865821519
* RLC[114] P2B-rlc2
Rrlc114 P2B nrlc114_1 0.402427795634
Lrlc114 nrlc114_1 nrlc114_2 6.27540980518e-09
Crlc114 nrlc114_2 rlc2 4.30550049032e-11
* RLC[115] P2B-rlc3
Rrlc115 P2B nrlc115_1 39.6363832969
Lrlc115 nrlc115_1 nrlc115_2 3.32506383634e-07
Crlc115 nrlc115_2 rlc3 2.32011017456e-10
* RLC[116] P2B-rlc4
Rrlc116 P2B nrlc116_1 11.5147447044
Lrlc116 nrlc116_1 nrlc116_2 3.67682073409e-07
Crlc116 nrlc116_2 rlc4 3.47460392513e-09
* RLC[117] P2B-rlc5
Rrlc117 P2B nrlc117_1 36.5508190681
Lrlc117 nrlc117_1 nrlc117_2 1.12974587437e-06
Crlc117 nrlc117_2 rlc5 4.55973771005e-10
* RLC[119] P2B-rlc7
Rrlc119 P2B nrlc119_1 25627.0764036
Lrlc119 nrlc119_1 nrlc119_2 0.135951826201
Crlc119 nrlc119_2 rlc7 0.001
* RLC[120] P2B-rlc8
Rrlc120 P2B nrlc120_1 10.1374165469
Lrlc120 nrlc120_1 nrlc120_2 3.1833439664e-06
Crlc120 nrlc120_2 rlc8 2.7644496166e-07
* RLC[122] P2B-rlc10
Rrlc122 P2B nrlc122_1 8.77783978544
Lrlc122 nrlc122_1 nrlc122_2 9.4743520742e-06
Crlc122 nrlc122_2 rlc10 7.70715237845e-06
* RLC[123] P2B-rlc11
Rrlc123 P2B nrlc123_1 12.7287420804
Lrlc123 nrlc123_1 nrlc123_2 4.60669314403e-05
Crlc123 nrlc123_2 rlc11 1.02592522573e-06
* RLC[124] P2B-rlc12
Rrlc124 P2B nrlc124_1 134.339377621
Lrlc124 nrlc124_1 nrlc124_2 1.2412025956e-06
Crlc124 nrlc124_2 rlc12 1.51209675053e-11
* RLC[128] P2B-P1B
Rrlc128 P2B nrlc128_1 27.9186913522
Lrlc128 nrlc128_1 nrlc128_2 4.42782191466e-07
Crlc128 nrlc128_2 P1B 7.52844048123e-10
* RLC[129] P3B-P4B
Rrlc129 P3B nrlc129_1 0.519386421981
Lrlc129 nrlc129_1 nrlc129_2 5.01167645063e-07
Crlc129 nrlc129_2 P4B 1.81592660102e-05
* RLC[132] P3B-rlc2
Rrlc132 P3B nrlc132_1 1320.91342058
Lrlc132 nrlc132_1 nrlc132_2 1.00305232859e-05
Crlc132 nrlc132_2 rlc2 7.71606739518e-10
* RLC[133] P3B-rlc3
Rrlc133 P3B nrlc133_1 22.3769837445
Lrlc133 nrlc133_1 nrlc133_2 0.000862663723807
Crlc133 nrlc133_2 rlc3 0.000406248375158
* RLC[135] P3B-rlc5
Rrlc135 P3B nrlc135_1 0.825968632173
Lrlc135 nrlc135_1 nrlc135_2 3.41510103228e-06
Crlc135 nrlc135_2 rlc5 0.000328240048738
* RLC[138] P3B-rlc8
Rrlc138 P3B nrlc138_1 3.99000885835
Lrlc138 nrlc138_1 nrlc138_2 3.14611780883e-06
Crlc138 nrlc138_2 rlc8 4.39241162617e-07
* RLC[139] P3B-rlc9
Rrlc139 P3B nrlc139_1 29.3539305416
Lrlc139 nrlc139_1 nrlc139_2 2.39513221129e-06
Crlc139 nrlc139_2 rlc9 3.08919207371e-08
* RLC[140] P3B-rlc10
Rrlc140 P3B nrlc140_1 162.999462976
Lrlc140 nrlc140_1 nrlc140_2 8.38391463643e-06
Crlc140 nrlc140_2 rlc10 3.79894525766e-10
* RLC[142] P3B-rlc12
Rrlc142 P3B nrlc142_1 42.9357495032
Lrlc142 nrlc142_1 nrlc142_2 1.1468028031e-07
Crlc142 nrlc142_2 rlc12 5.83349711942e-12
* RLC[145] P3B-rlc15
Rrlc145 P3B nrlc145_1 244.359507148
Lrlc145 nrlc145_1 nrlc145_2 2.07142400966e-05
Crlc145 nrlc145_2 rlc15 7.22882670357e-11
* RLC[146] P3B-P1B
Rrlc146 P3B nrlc146_1 103.312263875
Lrlc146 nrlc146_1 nrlc146_2 0.23441903773
Crlc146 nrlc146_2 P1B 9.36984093169e-05
* RLC[149] P4B-rlc2
Rrlc149 P4B nrlc149_1 0.251379972204
Lrlc149 nrlc149_1 nrlc149_2 6.89552800233e-08
Crlc149 nrlc149_2 rlc2 1.21244952934e-09
* RLC[150] P4B-rlc3
Rrlc150 P4B nrlc150_1 4.10765397158
Lrlc150 nrlc150_1 nrlc150_2 4.92056575033e-08
Crlc150 nrlc150_2 rlc3 3.370118723e-09
* RLC[153] P4B-rlc6
Rrlc153 P4B nrlc153_1 36.4211762395
Lrlc153 nrlc153_1 nrlc153_2 8.0334897186e-07
Crlc153 nrlc153_2 rlc6 4.45196451967e-10
* RLC[154] P4B-rlc7
Rrlc154 P4B nrlc154_1 0.0459308712484
Lrlc154 nrlc154_1 nrlc154_2 5.96121407408e-09
Crlc154 nrlc154_2 rlc7 1.73059455759e-07
* RLC[156] P4B-rlc9
Rrlc156 P4B nrlc156_1 2.96415318147
Lrlc156 nrlc156_1 nrlc156_2 1.87363273579e-07
Crlc156 nrlc156_2 rlc9 8.96946580169e-09
* RLC[157] P4B-rlc10
Rrlc157 P4B nrlc157_1 22.196334156
Lrlc157 nrlc157_1 nrlc157_2 1.34632595813e-05
Crlc157 nrlc157_2 rlc10 4.2720330392e-08
* RLC[159] P4B-rlc12
Rrlc159 P4B nrlc159_1 155.678750752
Lrlc159 nrlc159_1 nrlc159_2 1.25436615785e-06
Crlc159 nrlc159_2 rlc12 1.76526642691e-11
* RLC[161] P4B-rlc14
Rrlc161 P4B nrlc161_1 0.441415351179
Lrlc161 nrlc161_1 nrlc161_2 1.07392794521e-07
Crlc161 nrlc161_2 rlc14 7.88389507067e-10
* RLC[162] P4B-rlc15
Rrlc162 P4B nrlc162_1 1.98353201717
Lrlc162 nrlc162_1 nrlc162_2 1.31240669965e-08
Crlc162 nrlc162_2 rlc15 4.87594944698e-06
* RLC[166] rlc0-rlc3
Rrlc166 rlc0 nrlc166_1 0.255419179802
Lrlc166 nrlc166_1 nrlc166_2 6.17779992721e-10
Crlc166 nrlc166_2 rlc3 6.33757382029e-07
* RLC[167] rlc0-rlc4
Rrlc167 rlc0 nrlc167_1 27.3194330355
Lrlc167 nrlc167_1 nrlc167_2 3.36945726696e-06
Crlc167 nrlc167_2 rlc4 1.04862922182e-09
* RLC[170] rlc0-rlc7
Rrlc170 rlc0 nrlc170_1 41.443552305
Lrlc170 nrlc170_1 nrlc170_2 3.94918720461e-06
Crlc170 nrlc170_2 rlc7 9.81532313889e-11
* RLC[171] rlc0-rlc8
Rrlc171 rlc0 nrlc171_1 7.65317957003
Lrlc171 nrlc171_1 nrlc171_2 7.30545376476e-07
Crlc171 nrlc171_2 rlc8 1.57698704282e-08
* RLC[172] rlc0-rlc9
Rrlc172 rlc0 nrlc172_1 20.6744137634
Lrlc172 nrlc172_1 nrlc172_2 1.71925423198e-06
Crlc172 nrlc172_2 rlc9 3.54463963017e-09
* RLC[174] rlc0-rlc11
Rrlc174 rlc0 nrlc174_1 0.33198737865
Lrlc174 nrlc174_1 nrlc174_2 9.94779344668e-08
Crlc174 nrlc174_2 rlc11 1.6777265111e-09
* RLC[177] rlc0-rlc14
Rrlc177 rlc0 nrlc177_1 8.32671932801
Lrlc177 nrlc177_1 nrlc177_2 9.80517668915e-08
Crlc177 nrlc177_2 rlc14 8.92745627857e-10
* RLC[178] rlc0-rlc15
Rrlc178 rlc0 nrlc178_1 3.55532564666
Lrlc178 nrlc178_1 nrlc178_2 1.60530773023e-07
Crlc178 nrlc178_2 rlc15 2.91394624102e-10
* RLC[179] rlc0-P1B
Rrlc179 rlc0 nrlc179_1 0.677555867543
Lrlc179 nrlc179_1 nrlc179_2 1.06676077466e-05
Crlc179 nrlc179_2 P1B 0.001
* RLC[181] rlc1-rlc3
Rrlc181 rlc1 nrlc181_1 10.7906335321
Lrlc181 nrlc181_1 nrlc181_2 4.29874896639e-06
Crlc181 nrlc181_2 rlc3 4.1020947562e-11
* RLC[182] rlc1-rlc4
Rrlc182 rlc1 nrlc182_1 2.58193130919
Lrlc182 nrlc182_1 nrlc182_2 5.21342175099e-07
Crlc182 nrlc182_2 rlc4 8.68942386248e-11
* RLC[187] rlc1-rlc9
Rrlc187 rlc1 nrlc187_1 24.0376305028
Lrlc187 nrlc187_1 nrlc187_2 6.38100710331e-07
Crlc187 nrlc187_2 rlc9 2.24280094678e-10
* RLC[188] rlc1-rlc10
Rrlc188 rlc1 nrlc188_1 1.81983275145
Lrlc188 nrlc188_1 nrlc188_2 5.73000832105e-09
Crlc188 nrlc188_2 rlc10 9.93279391274e-10
* RLC[189] rlc1-rlc11
Rrlc189 rlc1 nrlc189_1 55.1784192162
Lrlc189 nrlc189_1 nrlc189_2 4.64508173938e-05
Crlc189 nrlc189_2 rlc11 1.69516642662e-11
* RLC[193] rlc1-rlc15
Rrlc193 rlc1 nrlc193_1 107.974110138
Lrlc193 nrlc193_1 nrlc193_2 4.07651230052e-06
Crlc193 nrlc193_2 rlc15 4.84876298676e-09
* RLC[197] rlc2-rlc5
Rrlc197 rlc2 nrlc197_1 119.95969177
Lrlc197 nrlc197_1 nrlc197_2 2.61501540569e-05
Crlc197 nrlc197_2 rlc5 2.01911502207e-12
* RLC[211] rlc3-rlc6
Rrlc211 rlc3 nrlc211_1 48.6288335116
Lrlc211 nrlc211_1 nrlc211_2 1.53984680825e-06
Crlc211 nrlc211_2 rlc6 8.07225664614e-11
* RLC[213] rlc3-rlc8
Rrlc213 rlc3 nrlc213_1 4.24233694859
Lrlc213 nrlc213_1 nrlc213_2 5.11870084141e-07
Crlc213 nrlc213_2 rlc8 2.29861754205e-09
* RLC[216] rlc3-rlc11
Rrlc216 rlc3 nrlc216_1 2.12343281082
Lrlc216 nrlc216_1 nrlc216_2 3.18861185313e-08
Crlc216 nrlc216_2 rlc11 3.35216282904e-08
* RLC[217] rlc3-rlc12
Rrlc217 rlc3 nrlc217_1 34.8261029123
Lrlc217 nrlc217_1 nrlc217_2 0.0022482419581
Crlc217 nrlc217_2 rlc12 2.25714947945e-05
* RLC[218] rlc3-rlc13
Rrlc218 rlc3 nrlc218_1 94.1406170878
Lrlc218 nrlc218_1 nrlc218_2 6.71035369507e-06
Crlc218 nrlc218_2 rlc13 3.48929440919e-12
* RLC[219] rlc3-rlc14
Rrlc219 rlc3 nrlc219_1 4.48657667666
Lrlc219 nrlc219_1 nrlc219_2 2.20101457894e-07
Crlc219 nrlc219_2 rlc14 2.56103455007e-10
* RLC[220] rlc3-rlc15
Rrlc220 rlc3 nrlc220_1 26.8011452223
Lrlc220 nrlc220_1 nrlc220_2 2.55116284325e-06
Crlc220 nrlc220_2 rlc15 3.12125103517e-11
* RLC[221] rlc3-P1B
Rrlc221 rlc3 nrlc221_1 0.0105211586292
Lrlc221 nrlc221_1 nrlc221_2 1.04631394857e-08
Crlc221 nrlc221_2 P1B 1.07303959189e-05
* RLC[222] rlc4-rlc5
Rrlc222 rlc4 nrlc222_1 7.57488893185
Lrlc222 nrlc222_1 nrlc222_2 1.39505677965e-06
Crlc222 nrlc222_2 rlc5 2.79695246148e-08
* RLC[223] rlc4-rlc6
Rrlc223 rlc4 nrlc223_1 22.1039185586
Lrlc223 nrlc223_1 nrlc223_2 1.82681883475e-06
Crlc223 nrlc223_2 rlc6 7.91219679558e-11
* RLC[225] rlc4-rlc8
Rrlc225 rlc4 nrlc225_1 0.476096959246
Lrlc225 nrlc225_1 nrlc225_2 6.1223870861e-10
Crlc225 nrlc225_2 rlc8 5.09320776389e-07
* RLC[230] rlc4-rlc13
Rrlc230 rlc4 nrlc230_1 124.901967078
Lrlc230 nrlc230_1 nrlc230_2 6.53665993271e-05
Crlc230 nrlc230_2 rlc13 4.65559106334e-12
* RLC[231] rlc4-rlc14
Rrlc231 rlc4 nrlc231_1 3.23801837295
Lrlc231 nrlc231_1 nrlc231_2 3.27789632356e-07
Crlc231 nrlc231_2 rlc14 4.51807310766e-09
* RLC[232] rlc4-rlc15
Rrlc232 rlc4 nrlc232_1 8.5276787
Lrlc232 nrlc232_1 nrlc232_2 9.16032611925e-08
Crlc232 nrlc232_2 rlc15 5.74668955711e-10
* RLC[233] rlc4-P1B
Rrlc233 rlc4 nrlc233_1 29.6811425699
Lrlc233 nrlc233_1 nrlc233_2 2.2892487951e-05
Crlc233 nrlc233_2 P1B 5.39061709695e-09
* RLC[234] rlc5-rlc6
Rrlc234 rlc5 nrlc234_1 15.6090304285
Lrlc234 nrlc234_1 nrlc234_2 1.09314940784e-07
Crlc234 nrlc234_2 rlc6 6.13142336013e-11
* RLC[235] rlc5-rlc7
Rrlc235 rlc5 nrlc235_1 3325.39657453
Lrlc235 nrlc235_1 nrlc235_2 0.0113149031702
Crlc235 nrlc235_2 rlc7 0.001
* RLC[237] rlc5-rlc9
Rrlc237 rlc5 nrlc237_1 70.2764874315
Lrlc237 nrlc237_1 nrlc237_2 1.7332154077e-06
Crlc237 nrlc237_2 rlc9 3.75217328888e-11
* RLC[239] rlc5-rlc11
Rrlc239 rlc5 nrlc239_1 0.16931269337
Lrlc239 nrlc239_1 nrlc239_2 2.11941556366e-07
Crlc239 nrlc239_2 rlc11 8.33853177011e-07
* RLC[240] rlc5-rlc12
Rrlc240 rlc5 nrlc240_1 7.09258820288
Lrlc240 nrlc240_1 nrlc240_2 0.022507472354
Crlc240 nrlc240_2 rlc12 0.000964575327964
* RLC[242] rlc5-rlc14
Rrlc242 rlc5 nrlc242_1 0.086224599001
Lrlc242 nrlc242_1 nrlc242_2 3.75726421253e-07
Crlc242 nrlc242_2 rlc14 5.61522108129e-08
* RLC[244] rlc5-P1B
Rrlc244 rlc5 nrlc244_1 13.6269076294
Lrlc244 nrlc244_1 nrlc244_2 0.0011690515663
Crlc244 nrlc244_2 P1B 0.000743770814062
* RLC[247] rlc6-rlc9
Rrlc247 rlc6 nrlc247_1 1116.53921456
Lrlc247 nrlc247_1 nrlc247_2 0.0607371921662
Crlc247 nrlc247_2 rlc9 6.90394918958e-09
* RLC[248] rlc6-rlc10
Rrlc248 rlc6 nrlc248_1 2.60885469348
Lrlc248 nrlc248_1 nrlc248_2 1.59194779408e-07
Crlc248 nrlc248_2 rlc10 5.37041342079e-08
* RLC[249] rlc6-rlc11
Rrlc249 rlc6 nrlc249_1 38.1565574364
Lrlc249 nrlc249_1 nrlc249_2 6.13294181077e-06
Crlc249 nrlc249_2 rlc11 4.6804538241e-12
* RLC[251] rlc6-rlc13
Rrlc251 rlc6 nrlc251_1 0.204005227497
Lrlc251 nrlc251_1 nrlc251_2 2.13225226929e-11
Crlc251 nrlc251_2 rlc13 1.69640036872e-10
* RLC[253] rlc6-rlc15
Rrlc253 rlc6 nrlc253_1 0.236281576621
Lrlc253 nrlc253_1 nrlc253_2 1.15030845002e-09
Crlc253 nrlc253_2 rlc15 2.35712797159e-11
* RLC[256] rlc7-rlc9
Rrlc256 rlc7 nrlc256_1 2202.38917353
Lrlc256 nrlc256_1 nrlc256_2 2.03939281902e-05
Crlc256 nrlc256_2 rlc9 5.67873306205e-08
* RLC[257] rlc7-rlc10
Rrlc257 rlc7 nrlc257_1 219.858208727
Lrlc257 nrlc257_1 nrlc257_2 1.8859407259e-05
Crlc257 nrlc257_2 rlc10 4.33511037081e-13
* RLC[258] rlc7-rlc11
Rrlc258 rlc7 nrlc258_1 11.9640650741
Lrlc258 nrlc258_1 nrlc258_2 1.9199176127e-06
Crlc258 nrlc258_2 rlc11 2.27453978849e-11
* RLC[260] rlc7-rlc13
Rrlc260 rlc7 nrlc260_1 26.2096152979
Lrlc260 nrlc260_1 nrlc260_2 1.25786796232e-06
Crlc260 nrlc260_2 rlc13 2.11537512281e-07
* RLC[262] rlc7-rlc15
Rrlc262 rlc7 nrlc262_1 1.53125808847
Lrlc262 nrlc262_1 nrlc262_2 1.49482703908e-08
Crlc262 nrlc262_2 rlc15 5.37634640374e-10
* RLC[263] rlc7-P1B
Rrlc263 rlc7 nrlc263_1 20.8684828364
Lrlc263 nrlc263_1 nrlc263_2 5.51412297914e-13
Crlc263 nrlc263_2 P1B 1.50023873519e-08
* RLC[264] rlc8-rlc9
Rrlc264 rlc8 nrlc264_1 9.48638061284
Lrlc264 nrlc264_1 nrlc264_2 3.63278538463e-07
Crlc264 nrlc264_2 rlc9 3.48828936021e-09
* RLC[265] rlc8-rlc10
Rrlc265 rlc8 nrlc265_1 0.0323855422885
Lrlc265 nrlc265_1 nrlc265_2 5.50719985151e-08
Crlc265 nrlc265_2 rlc10 3.30827868138e-07
* RLC[268] rlc8-rlc13
Rrlc268 rlc8 nrlc268_1 11.4267358176
Lrlc268 nrlc268_1 nrlc268_2 1.85421099755e-06
Crlc268 nrlc268_2 rlc13 2.28449003346e-11
* RLC[269] rlc8-rlc14
Rrlc269 rlc8 nrlc269_1 82.0832637422
Lrlc269 nrlc269_1 nrlc269_2 1.17049155448e-05
Crlc269 nrlc269_2 rlc14 1.37879144628e-11
* RLC[271] rlc8-P1B
Rrlc271 rlc8 nrlc271_1 0.170584798355
Lrlc271 nrlc271_1 nrlc271_2 9.22132268181e-07
Crlc271 nrlc271_2 P1B 0.000410467140849
* RLC[273] rlc9-rlc11
Rrlc273 rlc9 nrlc273_1 38.1770355609
Lrlc273 nrlc273_1 nrlc273_2 1.06442503185e-05
Crlc273 nrlc273_2 rlc11 8.11499849163e-12
* RLC[274] rlc9-rlc12
Rrlc274 rlc9 nrlc274_1 15.1049811067
Lrlc274 nrlc274_1 nrlc274_2 6.70874626684e-06
Crlc274 nrlc274_2 rlc12 3.26707033598e-11
* RLC[275] rlc9-rlc13
Rrlc275 rlc9 nrlc275_1 80.645523164
Lrlc275 nrlc275_1 nrlc275_2 1.37578656401e-11
Crlc275 nrlc275_2 rlc13 1.47438828122e-09
* RLC[277] rlc9-rlc15
Rrlc277 rlc9 nrlc277_1 1.37865833036
Lrlc277 nrlc277_1 nrlc277_2 1.23401495795e-07
Crlc277 nrlc277_2 rlc15 8.64870269124e-09
* RLC[278] rlc9-P1B
Rrlc278 rlc9 nrlc278_1 51.7200657455
Lrlc278 nrlc278_1 nrlc278_2 1.72769852986e-05
Crlc278 nrlc278_2 P1B 9.56107284251e-12
* RLC[281] rlc10-rlc13
Rrlc281 rlc10 nrlc281_1 0.720572056749
Lrlc281 nrlc281_1 nrlc281_2 1.00185340485e-06
Crlc281 nrlc281_2 rlc13 3.93776721801e-06
* RLC[282] rlc10-rlc14
Rrlc282 rlc10 nrlc282_1 32.5650117169
Lrlc282 nrlc282_1 nrlc282_2 1.54400641722e-05
Crlc282 nrlc282_2 rlc14 2.52217796613e-11
* RLC[288] rlc11-rlc15
Rrlc288 rlc11 nrlc288_1 161.561226234
Lrlc288 nrlc288_1 nrlc288_2 6.24812109651e-07
Crlc288 nrlc288_2 rlc15 4.15263878514e-07
* RLC[290] rlc12-rlc13
Rrlc290 rlc12 nrlc290_1 68.4033343016
Lrlc290 nrlc290_1 nrlc290_2 4.67825209275e-06
Crlc290 nrlc290_2 rlc13 2.94449431362e-11
* RLC[292] rlc12-rlc15
Rrlc292 rlc12 nrlc292_1 6.30970134291
Lrlc292 nrlc292_1 nrlc292_2 2.54823256759e-06
Crlc292 nrlc292_2 rlc15 7.11179035695e-11
* RLC[294] rlc13-rlc14
Rrlc294 rlc13 nrlc294_1 121.420427076
Lrlc294 nrlc294_1 nrlc294_2 3.51476642839e-06
Crlc294 nrlc294_2 rlc14 5.16181374626e-12
* RLC[298] rlc14-P1B
Rrlc298 rlc14 nrlc298_1 2.62720113765
Lrlc298 nrlc298_1 nrlc298_2 9.39081672497e-08
Crlc298 nrlc298_2 P1B 2.41629314671e-06
* RLC[299] rlc15-P1B
Rrlc299 rlc15 nrlc299_1 0.283085428696
Lrlc299 nrlc299_1 nrlc299_2 2.61767124787e-08
Crlc299 nrlc299_2 P1B 1.51735203312e-07
* DC[0] P1A-P2A
Rdc0 P1A ndc0_1 0.0123064884637
Ldc0 ndc0_1 P2A 8.12177219178e-08
* DC[23] P3A-P4A
Rdc23 P3A ndc23_1 0.116793809745
Ldc23 ndc23_1 P4A 7.33865023729e-08
* DC[42] P1B-P2B
Rdc42 P1B ndc42_1 0.113353991828
Ldc42 ndc42_1 P2B 3.81771050712e-08
* DC[44] P1B-P4B
Rdc44 P1B ndc44_1 53.1812809617
Ldc44 ndc44_1 P4B 8.46406374502e-06
* DC[47] P1B-dc2
Rdc47 P1B ndc47_1 0.88884234264
Ldc47 ndc47_1 dc2 2.2957593426e-06
* DC[48] P1B-dc3
Rdc48 P1B ndc48_1 0.010308694599
Ldc48 ndc48_1 dc3 4.57611912325e-06
* DC[51] P2B-P4B
Rdc51 P2B ndc51_1 510.525213173
Ldc51 ndc51_1 P4B 0.000408868824611
* DC[53] P2B-dc1
Rdc53 P2B ndc53_1 0.199752492608
Ldc53 ndc53_1 dc1 1.66398443335e-06
* DC[54] P2B-dc2
Rdc54 P2B ndc54_1 25.3083875487
Ldc54 ndc54_1 dc2 4.02795498006e-06
* DC[56] P2B-P1B
Rdc56 P2B ndc56_1 15.1151916773
Ldc56 ndc56_1 P1B 2.61950992379e-06
* DC[57] P3B-P4B
Rdc57 P3B ndc57_1 0.0144760150174
Ldc57 ndc57_1 P4B 1.20120375876e-07
* DC[58] P3B-dc0
Rdc58 P3B ndc58_1 0.17053112378
Ldc58 ndc58_1 dc0 2.74482700686e-08
* DC[59] P3B-dc1
Rdc59 P3B ndc59_1 0.543672717903
Ldc59 ndc59_1 dc1 0.000158886027237
* DC[62] P3B-P1B
Rdc62 P3B ndc62_1 361.773817915
Ldc62 ndc62_1 P1B 0.0004070186437
* DC[63] P4B-dc0
Rdc63 P4B ndc63_1 0.01
Ldc63 ndc63_1 dc0 9.9637799282e-06
* DC[64] P4B-dc1
Rdc64 P4B ndc64_1 0.0400179840574
Ldc64 ndc64_1 dc1 1.88982208335e-07
* DC[65] P4B-dc2
Rdc65 P4B ndc65_1 1.4917302731
Ldc65 ndc65_1 dc2 0.00157936903028
* DC[66] P4B-dc3
Rdc66 P4B ndc66_1 184.900369244
Ldc66 ndc66_1 dc3 0.169316063114
* DC[67] P4B-P1B
Rdc67 P4B ndc67_1 56.2802778239
Ldc67 ndc67_1 P1B 8.95728441425e-06
* DC[68] dc0-dc1
Rdc68 dc0 ndc68_1 0.01
Ldc68 ndc68_1 dc1 1.51219686862e-05
* DC[69] dc0-dc2
Rdc69 dc0 ndc69_1 0.125520813209
Ldc69 ndc69_1 dc2 1.99772578832e-08
* DC[72] dc1-dc2
Rdc72 dc1 ndc72_1 0.0100017029222
Ldc72 ndc72_1 dc2 0.000281567661966
* DC[73] dc1-dc3
Rdc73 dc1 ndc73_1 0.0103262726511
Ldc73 ndc73_1 dc3 8.975652601e-05
* DC[74] dc1-P1B
Rdc74 dc1 ndc74_1 7.0777805575
Ldc74 ndc74_1 P1B 1.12646376185e-06
* DC[75] dc2-dc3
Rdc75 dc2 ndc75_1 0.590428922755
Ldc75 ndc75_1 dc3 9.39696816008e-08
* DC[76] dc2-P1B
Rdc76 dc2 ndc76_1 0.610467295167
Ldc76 ndc76_1 P1B 1.50593504062e-06
* DC[77] dc3-P1B
Rdc77 dc3 ndc77_1 0.0101998820982
Ldc77 ndc77_1 P1B 3.59433975745e-06
* ---- leaks
Rleak_P1A P1A P1B 1e+12
Rleak_P2A P2A P1B 1e+12
Rleak_P2B P2B P1B 1e+12
Rleak_P3A P3A P1B 1e+12
Rleak_P3B P3B P1B 1e+12
Rleak_P4A P4A P1B 1e+12
Rleak_P4B P4B P1B 1e+12
Rleak_dc0 dc0 P1B 1e+12
Rleak_dc1 dc1 P1B 1e+12
Rleak_dc2 dc2 P1B 1e+12
Rleak_dc3 dc3 P1B 1e+12
Rleak_rlc0 rlc0 P1B 1e+12
Rleak_rlc1 rlc1 P1B 1e+12
Rleak_rlc10 rlc10 P1B 1e+12
Rleak_rlc11 rlc11 P1B 1e+12
Rleak_rlc12 rlc12 P1B 1e+12
Rleak_rlc13 rlc13 P1B 1e+12
Rleak_rlc14 rlc14 P1B 1e+12
Rleak_rlc15 rlc15 P1B 1e+12
Rleak_rlc2 rlc2 P1B 1e+12
Rleak_rlc3 rlc3 P1B 1e+12
Rleak_rlc4 rlc4 P1B 1e+12
Rleak_rlc5 rlc5 P1B 1e+12
Rleak_rlc6 rlc6 P1B 1e+12
Rleak_rlc7 rlc7 P1B 1e+12
Rleak_rlc8 rlc8 P1B 1e+12
Rleak_rlc9 rlc9 P1B 1e+12
.ends fitted
