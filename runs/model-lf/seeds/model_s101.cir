* fitted: 4-port fitted model, reference z0 = 50 Ohm
* port p is PpA (+) to PpB (-); the reference node is P1B
.subckt fitted P1A P1B P2A P2B P3A P3B P4A P4B
* ---- branches
* RLC[1] P1A-P3A
Rrlc1 P1A nrlc1_1 3842.523189
Lrlc1 nrlc1_1 nrlc1_2 3.71513987075e-10
Crlc1 nrlc1_2 P3A 3.46217279163e-14
* RLC[3] P1A-P1B
Rrlc3 P1A nrlc3_1 43673.1274757
Lrlc3 nrlc3_1 nrlc3_2 0.00774365447697
Crlc3 nrlc3_2 P1B 4.51102122403e-15
* RLC[5] P1A-P3B
Rrlc5 P1A nrlc5_1 625419612858
Lrlc5 nrlc5_1 nrlc5_2 1
Crlc5 nrlc5_2 P3B 1.03426442064e-05
* RLC[7] P1A-rlc0
Rrlc7 P1A nrlc7_1 21.8052539609
Lrlc7 nrlc7_1 nrlc7_2 9.34026526552e-07
Crlc7 nrlc7_2 rlc0 2.18270178035e-12
* RLC[10] P1A-rlc3
Rrlc10 P1A nrlc10_1 119394.850159
Lrlc10 nrlc10_1 nrlc10_2 0.00252840861975
Crlc10 nrlc10_2 rlc3 5.36595786533e-14
* RLC[11] P1A-rlc4
Rrlc11 P1A nrlc11_1 193291319179
Lrlc11 nrlc11_1 nrlc11_2 0.99959211486
Crlc11 nrlc11_2 rlc4 4.29683962639e-09
* RLC[17] P1A-rlc10
Rrlc17 P1A nrlc17_1 679191019936
Lrlc17 nrlc17_1 nrlc17_2 0.999962655141
Crlc17 nrlc17_2 rlc10 0.000158963083039
* RLC[18] P1A-rlc11
Rrlc18 P1A nrlc18_1 155.277681641
Lrlc18 nrlc18_1 nrlc18_2 6.6914296709e-06
Crlc18 nrlc18_2 rlc11 3.08360209339e-13
* RLC[21] P1A-rlc14
Rrlc21 P1A nrlc21_1 27815427.0292
Lrlc21 nrlc21_1 nrlc21_2 0.844866593526
Crlc21 nrlc21_2 rlc14 3.0045886987e-14
* RLC[22] P1A-rlc15
Rrlc22 P1A nrlc22_1 180356.200536
Lrlc22 nrlc22_1 nrlc22_2 0.00241376114601
Crlc22 nrlc22_2 rlc15 1.12521216321e-13
* RLC[26] P2A-P1B
Rrlc26 P2A nrlc26_1 517146696832
Lrlc26 nrlc26_1 nrlc26_2 0.999948101278
Crlc26 nrlc26_2 P1B 3.85760080256e-06
* RLC[27] P2A-P2B
Rrlc27 P2A nrlc27_1 3265.37774583
Lrlc27 nrlc27_1 nrlc27_2 0.000408842766181
Crlc27 nrlc27_2 P2B 4.26036640413e-14
* RLC[31] P2A-rlc1
Rrlc31 P2A nrlc31_1 4442812.85786
Lrlc31 nrlc31_1 nrlc31_2 0.0994257211044
Crlc31 nrlc31_2 rlc1 1.86690315979e-13
* RLC[36] P2A-rlc6
Rrlc36 P2A nrlc36_1 341485.943665
Lrlc36 nrlc36_1 nrlc36_2 2.2980026853e-08
Crlc36 nrlc36_2 rlc6 3.1550706684e-13
* RLC[37] P2A-rlc7
Rrlc37 P2A nrlc37_1 9132.76774169
Lrlc37 nrlc37_1 nrlc37_2 7.73640056858e-05
Crlc37 nrlc37_2 rlc7 4.43567001222e-13
* RLC[38] P2A-rlc8
Rrlc38 P2A nrlc38_1 289.591641635
Lrlc38 nrlc38_1 nrlc38_2 5.93193130163e-07
Crlc38 nrlc38_2 rlc8 1.7835698357e-12
* RLC[41] P2A-rlc11
Rrlc41 P2A nrlc41_1 7.66690604788
Lrlc41 nrlc41_1 nrlc41_2 3.10567370035e-07
Crlc41 nrlc41_2 rlc11 5.87047215234e-12
* RLC[42] P2A-rlc12
Rrlc42 P2A nrlc42_1 1.00049518295e+12
Lrlc42 nrlc42_1 nrlc42_2 0.999986252851
Crlc42 nrlc42_2 rlc12 4.7599374177e-08
* RLC[43] P2A-rlc13
Rrlc43 P2A nrlc43_1 52.1093470892
Lrlc43 nrlc43_1 nrlc43_2 2.06951462787e-06
Crlc43 nrlc43_2 rlc13 8.46827060867e-13
* RLC[46] P2A-P1B
Rrlc46 P2A nrlc46_1 25598.3509195
Lrlc46 nrlc46_1 nrlc46_2 0.00453925344504
Crlc46 nrlc46_2 P1B 7.69693724501e-15
* RLC[48] P3A-P1B
Rrlc48 P3A nrlc48_1 2516.0114419
Lrlc48 nrlc48_1 nrlc48_2 0.000398800343073
Crlc48 nrlc48_2 P1B 6.99983479488e-14
* RLC[49] P3A-P2B
Rrlc49 P3A nrlc49_1 45083.0369161
Lrlc49 nrlc49_1 nrlc49_2 0.000275255206555
Crlc49 nrlc49_2 P2B 2.54654760997e-13
* RLC[51] P3A-P4B
Rrlc51 P3A nrlc51_1 13581.911022
Lrlc51 nrlc51_1 nrlc51_2 0.00430874884536
Crlc51 nrlc51_2 P4B 2.59529606719e-14
* RLC[52] P3A-rlc0
Rrlc52 P3A nrlc52_1 3826.52842811
Lrlc52 nrlc52_1 nrlc52_2 0.000765535213289
Crlc52 nrlc52_2 rlc0 5.80915245947e-14
* RLC[53] P3A-rlc1
Rrlc53 P3A nrlc53_1 3277.90233471
Lrlc53 nrlc53_1 nrlc53_2 0.00036317081359
Crlc53 nrlc53_2 rlc1 3.7555747485e-14
* RLC[57] P3A-rlc5
Rrlc57 P3A nrlc57_1 5029.92037291
Lrlc57 nrlc57_1 nrlc57_2 0.00112116157661
Crlc57 nrlc57_2 rlc5 4.92383483242e-14
* RLC[58] P3A-rlc6
Rrlc58 P3A nrlc58_1 874798.610535
Lrlc58 nrlc58_1 nrlc58_2 9.61463117061e-06
Crlc58 nrlc58_2 rlc6 4.16998327276e-13
* RLC[59] P3A-rlc7
Rrlc59 P3A nrlc59_1 947.063990831
Lrlc59 nrlc59_1 nrlc59_2 8.80490838014e-12
Crlc59 nrlc59_2 rlc7 7.30970521064e-14
* RLC[60] P3A-rlc8
Rrlc60 P3A nrlc60_1 0.0127781352772
Lrlc60 nrlc60_1 nrlc60_2 2.48895702051e-12
Crlc60 nrlc60_2 rlc8 1.69371340483e-11
* RLC[61] P3A-rlc9
Rrlc61 P3A nrlc61_1 3557.68824252
Lrlc61 nrlc61_1 nrlc61_2 0.000625889948763
Crlc61 nrlc61_2 rlc9 5.49439262753e-14
* RLC[63] P3A-rlc11
Rrlc63 P3A nrlc63_1 195604929340
Lrlc63 nrlc63_1 nrlc63_2 0.924877413648
Crlc63 nrlc63_2 rlc11 1.14297134408e-08
* RLC[64] P3A-rlc12
Rrlc64 P3A nrlc64_1 368745307795
Lrlc64 nrlc64_1 nrlc64_2 0.815908693697
Crlc64 nrlc64_2 rlc12 4.13193825643e-09
* RLC[65] P3A-rlc13
Rrlc65 P3A nrlc65_1 12846893.5586
Lrlc65 nrlc65_1 nrlc65_2 1.36720964653e-05
Crlc65 nrlc65_2 rlc13 1.38536586772e-13
* RLC[66] P3A-rlc14
Rrlc66 P3A nrlc66_1 2487.99520888
Lrlc66 nrlc66_1 nrlc66_2 0.000351361614052
Crlc66 nrlc66_2 rlc14 6.30685323283e-14
* RLC[67] P3A-rlc15
Rrlc67 P3A nrlc67_1 4482.78764966
Lrlc67 nrlc67_1 nrlc67_2 0.000494500932057
Crlc67 nrlc67_2 rlc15 2.73418736193e-14
* RLC[68] P3A-P1B
Rrlc68 P3A nrlc68_1 2079.39251596
Lrlc68 nrlc68_1 nrlc68_2 0.000261559331984
Crlc68 nrlc68_2 P1B 6.72132285471e-14
* RLC[71] P4A-P3B
Rrlc71 P4A nrlc71_1 21997.0618007
Lrlc71 nrlc71_1 nrlc71_2 0.00879538382546
Crlc71 nrlc71_2 P3B 2.01968173155e-14
* RLC[78] P4A-rlc5
Rrlc78 P4A nrlc78_1 4010.02351471
Lrlc78 nrlc78_1 nrlc78_2 0.00039308085797
Crlc78 nrlc78_2 rlc5 2.71609869718e-14
* RLC[79] P4A-rlc6
Rrlc79 P4A nrlc79_1 5678.52885842
Lrlc79 nrlc79_1 nrlc79_2 0.00141876301807
Crlc79 nrlc79_2 rlc6 4.88872576031e-14
* RLC[82] P4A-rlc9
Rrlc82 P4A nrlc82_1 3594.30196603
Lrlc82 nrlc82_1 nrlc82_2 0.000352343976855
Crlc82 nrlc82_2 rlc9 3.03036695499e-14
* RLC[84] P4A-rlc11
Rrlc84 P4A nrlc84_1 5087.60245656
Lrlc84 nrlc84_1 nrlc84_2 0.000209276034526
Crlc84 nrlc84_2 rlc11 8.98360506521e-15
* RLC[85] P4A-rlc12
Rrlc85 P4A nrlc85_1 2251.70045929
Lrlc85 nrlc85_1 nrlc85_2 6.84633953111e-05
Crlc85 nrlc85_2 rlc12 1.50035728413e-14
* RLC[86] P4A-rlc13
Rrlc86 P4A nrlc86_1 12062.4889207
Lrlc86 nrlc86_1 nrlc86_2 0.00169296039201
Crlc86 nrlc86_2 rlc13 1.29279729061e-14
* RLC[88] P4A-rlc15
Rrlc88 P4A nrlc88_1 2688.37316129
Lrlc88 nrlc88_1 nrlc88_2 0.000113130247324
Crlc88 nrlc88_2 rlc15 1.7392304286e-14
* RLC[89] P4A-P1B
Rrlc89 P4A nrlc89_1 107465.105634
Lrlc89 nrlc89_1 nrlc89_2 0.000749177137968
Crlc89 nrlc89_2 P1B 4.21237818927e-13
* RLC[90] P1B-P2B
Rrlc90 P1B nrlc90_1 0.30522294723
Lrlc90 nrlc90_1 nrlc90_2 4.16685335673e-07
Crlc90 nrlc90_2 P2B 1.97504303813e-05
* RLC[94] P1B-rlc1
Rrlc94 P1B nrlc94_1 22.3448406218
Lrlc94 nrlc94_1 nrlc94_2 5.44743517724e-06
Crlc94 nrlc94_2 rlc1 2.15960961922e-11
* RLC[95] P1B-rlc2
Rrlc95 P1B nrlc95_1 3.02889561291
Lrlc95 nrlc95_1 nrlc95_2 5.18771809653e-07
Crlc95 nrlc95_2 rlc2 6.28297376742e-11
* RLC[96] P1B-rlc3
Rrlc96 P1B nrlc96_1 3.05984217224
Lrlc96 nrlc96_1 nrlc96_2 6.3896308601e-07
Crlc96 nrlc96_2 rlc3 4.33204955072e-06
* RLC[97] P1B-rlc4
Rrlc97 P1B nrlc97_1 0.952590842784
Lrlc97 nrlc97_1 nrlc97_2 7.82334760763e-08
Crlc97 nrlc97_2 rlc4 6.22809226133e-07
* RLC[98] P1B-rlc5
Rrlc98 P1B nrlc98_1 73.4370383592
Lrlc98 nrlc98_1 nrlc98_2 1.30772987638e-06
Crlc98 nrlc98_2 rlc5 7.8505220284e-10
* RLC[99] P1B-rlc6
Rrlc99 P1B nrlc99_1 30.8449168998
Lrlc99 nrlc99_1 nrlc99_2 1.03792528826e-05
Crlc99 nrlc99_2 rlc6 1.21215002513e-11
* RLC[100] P1B-rlc7
Rrlc100 P1B nrlc100_1 1.2663836129
Lrlc100 nrlc100_1 nrlc100_2 2.73396865318e-06
Crlc100 nrlc100_2 rlc7 5.00880084779e-05
* RLC[101] P1B-rlc8
Rrlc101 P1B nrlc101_1 5.74374940304
Lrlc101 nrlc101_1 nrlc101_2 5.18598563476e-07
Crlc101 nrlc101_2 rlc8 3.71954626487e-08
* RLC[102] P1B-rlc9
Rrlc102 P1B nrlc102_1 13.2595158628
Lrlc102 nrlc102_1 nrlc102_2 3.36209321837e-07
Crlc102 nrlc102_2 rlc9 1.00348232959e-10
* RLC[103] P1B-rlc10
Rrlc103 P1B nrlc103_1 30.2580832948
Lrlc103 nrlc103_1 nrlc103_2 2.25131777971e-06
Crlc103 nrlc103_2 rlc10 8.73198027341e-11
* RLC[104] P1B-rlc11
Rrlc104 P1B nrlc104_1 2.94439676973
Lrlc104 nrlc104_1 nrlc104_2 4.99016904572e-07
Crlc104 nrlc104_2 rlc11 6.39558217283e-11
* RLC[105] P1B-rlc12
Rrlc105 P1B nrlc105_1 17.9211702834
Lrlc105 nrlc105_1 nrlc105_2 1.24791798567e-06
Crlc105 nrlc105_2 rlc12 3.4892147751e-11
* RLC[108] P1B-rlc15
Rrlc108 P1B nrlc108_1 36.9564327311
Lrlc108 nrlc108_1 nrlc108_2 1.72121062566e-06
Crlc108 nrlc108_2 rlc15 5.13553448457e-12
* RLC[112] P2B-rlc0
Rrlc112 P2B nrlc112_1 150.516414682
Lrlc112 nrlc112_1 nrlc112_2 2.57247016234e-06
Crlc112 nrlc112_2 rlc0 7.88105788347e-11
* RLC[115] P2B-rlc3
Rrlc115 P2B nrlc115_1 0.821718703816
Lrlc115 nrlc115_1 nrlc115_2 2.02854597909e-07
Crlc115 nrlc115_2 rlc3 2.23075971459e-07
* RLC[116] P2B-rlc4
Rrlc116 P2B nrlc116_1 0.0109392494056
Lrlc116 nrlc116_1 nrlc116_2 5.45087239302e-06
Crlc116 nrlc116_2 rlc4 0.000875858368084
* RLC[121] P2B-rlc9
Rrlc121 P2B nrlc121_1 0.173014301506
Lrlc121 nrlc121_1 nrlc121_2 2.02252719695e-06
Crlc121 nrlc121_2 rlc9 8.84018579579e-05
* RLC[124] P2B-rlc12
Rrlc124 P2B nrlc124_1 402.76299902
Lrlc124 nrlc124_1 nrlc124_2 9.11745429138e-13
Crlc124 nrlc124_2 rlc12 1.26754846273e-07
* RLC[127] P2B-rlc15
Rrlc127 P2B nrlc127_1 67.7494563495
Lrlc127 nrlc127_1 nrlc127_2 2.32198274843e-06
Crlc127 nrlc127_2 rlc15 2.77698479833e-10
* RLC[128] P2B-P1B
Rrlc128 P2B nrlc128_1 0.276734680485
Lrlc128 nrlc128_1 nrlc128_2 1.4748323624e-07
Crlc128 nrlc128_2 P1B 0.000274660529601
* RLC[130] P3B-rlc0
Rrlc130 P3B nrlc130_1 1.2365811369
Lrlc130 nrlc130_1 nrlc130_2 1.07133056428e-06
Crlc130 nrlc130_2 rlc0 0.000135540474023
* RLC[135] P3B-rlc5
Rrlc135 P3B nrlc135_1 15.3688702284
Lrlc135 nrlc135_1 nrlc135_2 1.11732292374e-06
Crlc135 nrlc135_2 rlc5 2.30743407762e-08
* RLC[140] P3B-rlc10
Rrlc140 P3B nrlc140_1 530.997781133
Lrlc140 nrlc140_1 nrlc140_2 2.46056721365e-05
Crlc140 nrlc140_2 rlc10 7.99455807437e-12
* RLC[141] P3B-rlc11
Rrlc141 P3B nrlc141_1 5629.31017179
Lrlc141 nrlc141_1 nrlc141_2 0.0260137355631
Crlc141 nrlc141_2 rlc11 6.22933448261e-05
* RLC[143] P3B-rlc13
Rrlc143 P3B nrlc143_1 20.8138393667
Lrlc143 nrlc143_1 nrlc143_2 3.95017726002e-06
Crlc143 nrlc143_2 rlc13 1.68392038116e-07
* RLC[144] P3B-rlc14
Rrlc144 P3B nrlc144_1 666.848715638
Lrlc144 nrlc144_1 nrlc144_2 2.82952439908e-13
Crlc144 nrlc144_2 rlc14 2.79426478376e-09
* RLC[145] P3B-rlc15
Rrlc145 P3B nrlc145_1 724.527633859
Lrlc145 nrlc145_1 nrlc145_2 5.4986700123e-05
Crlc145 nrlc145_2 rlc15 8.13536145253e-12
* RLC[146] P3B-P1B
Rrlc146 P3B nrlc146_1 367.622696245
Lrlc146 nrlc146_1 nrlc146_2 6.4547351504e-06
Crlc146 nrlc146_2 P1B 1.78353721013e-10
* RLC[147] P4B-rlc0
Rrlc147 P4B nrlc147_1 0.01
Lrlc147 nrlc147_1 nrlc147_2 3.95866021939e-05
Crlc147 nrlc147_2 rlc0 0.000999804770006
* RLC[148] P4B-rlc1
Rrlc148 P4B nrlc148_1 51.6008568463
Lrlc148 nrlc148_1 nrlc148_2 1.29188800174e-05
Crlc148 nrlc148_2 rlc1 7.32901092375e-12
* RLC[151] P4B-rlc4
Rrlc151 P4B nrlc151_1 47.8226130941
Lrlc151 nrlc151_1 nrlc151_2 0.414453419225
Crlc151 nrlc151_2 rlc4 0.000791683585389
* RLC[152] P4B-rlc5
Rrlc152 P4B nrlc152_1 0.503059899266
Lrlc152 nrlc152_1 nrlc152_2 0.0328743093104
Crlc152 nrlc152_2 rlc5 0.000903558064839
* RLC[156] P4B-rlc9
Rrlc156 P4B nrlc156_1 0.01
Lrlc156 nrlc156_1 nrlc156_2 2.80064493664e-08
Crlc156 nrlc156_2 rlc9 0.000127111993905
* RLC[159] P4B-rlc12
Rrlc159 P4B nrlc159_1 0.997025762223
Lrlc159 nrlc159_1 nrlc159_2 5.77860680693e-14
Crlc159 nrlc159_2 rlc12 1.65885067896e-11
* RLC[160] P4B-rlc13
Rrlc160 P4B nrlc160_1 0.125929265876
Lrlc160 nrlc160_1 nrlc160_2 7.21094213922e-07
Crlc160 nrlc160_2 rlc13 5.05238175532e-08
* RLC[164] rlc0-rlc1
Rrlc164 rlc0 nrlc164_1 50.1446857838
Lrlc164 nrlc164_1 nrlc164_2 6.31278044726e-06
Crlc164 nrlc164_2 rlc1 2.78951272714e-12
* RLC[165] rlc0-rlc2
Rrlc165 rlc0 nrlc165_1 18.0978388339
Lrlc165 nrlc165_1 nrlc165_2 1.20059261465e-06
Crlc165 nrlc165_2 rlc2 9.68753047951e-11
* RLC[166] rlc0-rlc3
Rrlc166 rlc0 nrlc166_1 36.8197256886
Lrlc166 nrlc166_1 nrlc166_2 1.98634820535e-05
Crlc166 nrlc166_2 rlc3 5.08016135471e-07
* RLC[168] rlc0-rlc5
Rrlc168 rlc0 nrlc168_1 8.02360502111
Lrlc168 nrlc168_1 nrlc168_2 4.27896803021e-07
Crlc168 nrlc168_2 rlc5 2.18420960753e-07
* RLC[169] rlc0-rlc6
Rrlc169 rlc0 nrlc169_1 27.5256162393
Lrlc169 nrlc169_1 nrlc169_2 2.21447923088e-13
Crlc169 nrlc169_2 rlc6 1.1847224696e-07
* RLC[170] rlc0-rlc7
Rrlc170 rlc0 nrlc170_1 6.31578227512
Lrlc170 nrlc170_1 nrlc170_2 1.78879319151e-14
Crlc170 nrlc170_2 rlc7 1.32283946925e-08
* RLC[172] rlc0-rlc9
Rrlc172 rlc0 nrlc172_1 45.188249177
Lrlc172 nrlc172_1 nrlc172_2 8.31824787849e-06
Crlc172 nrlc172_2 rlc9 4.52624771656e-12
* RLC[173] rlc0-rlc10
Rrlc173 rlc0 nrlc173_1 6.2066133836
Lrlc173 nrlc173_1 nrlc173_2 3.80811281265e-07
Crlc173 nrlc173_2 rlc10 6.00376424256e-11
* RLC[174] rlc0-rlc11
Rrlc174 rlc0 nrlc174_1 738.544796788
Lrlc174 nrlc174_1 nrlc174_2 1
Crlc174 nrlc174_2 rlc11 0.001
* RLC[178] rlc0-rlc15
Rrlc178 rlc0 nrlc178_1 64.4448777775
Lrlc178 nrlc178_1 nrlc178_2 2.06013596728e-05
Crlc178 nrlc178_2 rlc15 9.35554353635e-12
* RLC[179] rlc0-P1B
Rrlc179 rlc0 nrlc179_1 36.9679235976
Lrlc179 nrlc179_1 nrlc179_2 1.63546885698e-06
Crlc179 nrlc179_2 P1B 8.97989852816e-11
* RLC[180] rlc1-rlc2
Rrlc180 rlc1 nrlc180_1 67.0654105252
Lrlc180 nrlc180_1 nrlc180_2 0.00581419863773
Crlc180 nrlc180_2 rlc2 8.06644251767e-05
* RLC[182] rlc1-rlc4
Rrlc182 rlc1 nrlc182_1 116.660466488
Lrlc182 nrlc182_1 nrlc182_2 2.58213555886e-05
Crlc182 nrlc182_2 rlc4 5.99564285349e-11
* RLC[183] rlc1-rlc5
Rrlc183 rlc1 nrlc183_1 576.329194169
Lrlc183 nrlc183_1 nrlc183_2 0.000317987116374
Crlc183 nrlc183_2 rlc5 3.05357323202e-11
* RLC[184] rlc1-rlc6
Rrlc184 rlc1 nrlc184_1 7.27400368245
Lrlc184 nrlc184_1 nrlc184_2 2.71297899977e-06
Crlc184 nrlc184_2 rlc6 5.69713996889e-11
* RLC[185] rlc1-rlc7
Rrlc185 rlc1 nrlc185_1 1.16742284031
Lrlc185 nrlc185_1 nrlc185_2 8.07383372678e-07
Crlc185 nrlc185_2 rlc7 1.01384021246e-09
* RLC[186] rlc1-rlc8
Rrlc186 rlc1 nrlc186_1 0.112243545505
Lrlc186 nrlc186_1 nrlc186_2 1.07016217845e-08
Crlc186 nrlc186_2 rlc8 9.43809480661e-10
* RLC[187] rlc1-rlc9
Rrlc187 rlc1 nrlc187_1 385.209231306
Lrlc187 nrlc187_1 nrlc187_2 0.658195477321
Crlc187 nrlc187_2 rlc9 0.000741922865045
* RLC[189] rlc1-rlc11
Rrlc189 rlc1 nrlc189_1 1.31765280664
Lrlc189 nrlc189_1 nrlc189_2 0.286283630999
Crlc189 nrlc189_2 rlc11 0.000198759841777
* RLC[191] rlc1-rlc13
Rrlc191 rlc1 nrlc191_1 2.80126839181
Lrlc191 nrlc191_1 nrlc191_2 1.85238205467e-07
Crlc191 nrlc191_2 rlc13 1.09201246272e-10
* RLC[192] rlc1-rlc14
Rrlc192 rlc1 nrlc192_1 40.5453566274
Lrlc192 nrlc192_1 nrlc192_2 1.97925156419e-06
Crlc192 nrlc192_2 rlc14 9.57382719514e-11
* RLC[194] rlc1-P1B
Rrlc194 rlc1 nrlc194_1 0.162644201006
Lrlc194 nrlc194_1 nrlc194_2 0.0011811321115
Crlc194 nrlc194_2 P1B 0.000925151165996
* RLC[196] rlc2-rlc4
Rrlc196 rlc2 nrlc196_1 2258.66548152
Lrlc196 nrlc196_1 nrlc196_2 0.00375443221305
Crlc196 nrlc196_2 rlc4 0.000104377212255
* RLC[198] rlc2-rlc6
Rrlc198 rlc2 nrlc198_1 174.181085532
Lrlc198 nrlc198_1 nrlc198_2 0.238229304463
Crlc198 nrlc198_2 rlc6 0.000636561249776
* RLC[203] rlc2-rlc11
Rrlc203 rlc2 nrlc203_1 8.32867797878
Lrlc203 nrlc203_1 nrlc203_2 1.56297804367e-06
Crlc203 nrlc203_2 rlc11 4.08273352765e-11
* RLC[204] rlc2-rlc12
Rrlc204 rlc2 nrlc204_1 2.55283741458
Lrlc204 nrlc204_1 nrlc204_2 5.20214100645e-07
Crlc204 nrlc204_2 rlc12 8.86980270265e-11
* RLC[205] rlc2-rlc13
Rrlc205 rlc2 nrlc205_1 2.49486619821
Lrlc205 nrlc205_1 nrlc205_2 0.830084264423
Crlc205 nrlc205_2 rlc13 0.000979520247304
* RLC[208] rlc2-P1B
Rrlc208 rlc2 nrlc208_1 17.0561674953
Lrlc208 nrlc208_1 nrlc208_2 0.127030112134
Crlc208 nrlc208_2 P1B 0.000150355326529
* RLC[210] rlc3-rlc5
Rrlc210 rlc3 nrlc210_1 12.1076294294
Lrlc210 nrlc210_1 nrlc210_2 2.11797932337e-07
Crlc210 nrlc210_2 rlc5 1.39152012298e-10
* RLC[211] rlc3-rlc6
Rrlc211 rlc3 nrlc211_1 61.6884213445
Lrlc211 nrlc211_1 nrlc211_2 1.18428743589e-06
Crlc211 nrlc211_2 rlc6 4.85265628834e-11
* RLC[212] rlc3-rlc7
Rrlc212 rlc3 nrlc212_1 6.73022505202
Lrlc212 nrlc212_1 nrlc212_2 5.78155918078e-07
Crlc212 nrlc212_2 rlc7 8.09385371658e-11
* RLC[213] rlc3-rlc8
Rrlc213 rlc3 nrlc213_1 83.971328878
Lrlc213 nrlc213_1 nrlc213_2 3.05257650423e-06
Crlc213 nrlc213_2 rlc8 1.13566520258e-11
* RLC[215] rlc3-rlc10
Rrlc215 rlc3 nrlc215_1 2.16977933855
Lrlc215 nrlc215_1 nrlc215_2 1.39909004729e-07
Crlc215 nrlc215_2 rlc10 3.4096960172e-10
* RLC[219] rlc3-rlc14
Rrlc219 rlc3 nrlc219_1 14.3120185709
Lrlc219 nrlc219_1 nrlc219_2 4.91029547826e-07
Crlc219 nrlc219_2 rlc14 8.33606290459e-11
* RLC[220] rlc3-rlc15
Rrlc220 rlc3 nrlc220_1 25.560669255
Lrlc220 nrlc220_1 nrlc220_2 1.3198091883e-06
Crlc220 nrlc220_2 rlc15 6.4673619127e-10
* RLC[221] rlc3-P1B
Rrlc221 rlc3 nrlc221_1 2.85364732127
Lrlc221 nrlc221_1 nrlc221_2 3.57774681447e-08
Crlc221 nrlc221_2 P1B 1.52175486936e-07
* RLC[222] rlc4-rlc5
Rrlc222 rlc4 nrlc222_1 35.0241276274
Lrlc222 nrlc222_1 nrlc222_2 0.0702597791506
Crlc222 nrlc222_2 rlc5 0.000953410546076
* RLC[223] rlc4-rlc6
Rrlc223 rlc4 nrlc223_1 435.476575219
Lrlc223 nrlc223_1 nrlc223_2 0.923373027245
Crlc223 nrlc223_2 rlc6 0.000386748521521
* RLC[224] rlc4-rlc7
Rrlc224 rlc4 nrlc224_1 2.92925070127
Lrlc224 nrlc224_1 nrlc224_2 3.84932630612e-07
Crlc224 nrlc224_2 rlc7 5.42808838181e-06
* RLC[225] rlc4-rlc8
Rrlc225 rlc4 nrlc225_1 19.6329311356
Lrlc225 nrlc225_1 nrlc225_2 5.01689751315e-06
Crlc225 nrlc225_2 rlc8 1.44618027341e-11
* RLC[226] rlc4-rlc9
Rrlc226 rlc4 nrlc226_1 0.799267116301
Lrlc226 nrlc226_1 nrlc226_2 1.31029473799e-07
Crlc226 nrlc226_2 rlc9 1.53886544451e-05
* RLC[227] rlc4-rlc10
Rrlc227 rlc4 nrlc227_1 431.568431438
Lrlc227 nrlc227_1 nrlc227_2 0.684218428006
Crlc227 nrlc227_2 rlc10 0.000999978551257
* RLC[228] rlc4-rlc11
Rrlc228 rlc4 nrlc228_1 2.92045690652
Lrlc228 nrlc228_1 nrlc228_2 4.50334441577e-07
Crlc228 nrlc228_2 rlc11 5.88794382726e-11
* RLC[230] rlc4-rlc13
Rrlc230 rlc4 nrlc230_1 76.7610134881
Lrlc230 nrlc230_1 nrlc230_2 2.44418819294e-05
Crlc230 nrlc230_2 rlc13 5.68378210697e-12
* RLC[231] rlc4-rlc14
Rrlc231 rlc4 nrlc231_1 0.645742006135
Lrlc231 nrlc231_1 nrlc231_2 1.10741854491e-07
Crlc231 nrlc231_2 rlc14 5.3118694713e-10
* RLC[233] rlc4-P1B
Rrlc233 rlc4 nrlc233_1 1.7715702724
Lrlc233 nrlc233_1 nrlc233_2 9.61983599812e-08
Crlc233 nrlc233_2 P1B 2.79042293841e-09
* RLC[234] rlc5-rlc6
Rrlc234 rlc5 nrlc234_1 5.69200747664
Lrlc234 nrlc234_1 nrlc234_2 2.11126004878e-06
Crlc234 nrlc234_2 rlc6 7.24049564196e-11
* RLC[235] rlc5-rlc7
Rrlc235 rlc5 nrlc235_1 5.18096811039
Lrlc235 nrlc235_1 nrlc235_2 5.98993981772e-08
Crlc235 nrlc235_2 rlc7 8.71412748071e-09
* RLC[236] rlc5-rlc8
Rrlc236 rlc5 nrlc236_1 0.0116480854574
Lrlc236 nrlc236_1 nrlc236_2 7.96455576034e-08
Crlc236 nrlc236_2 rlc8 6.52243787531e-07
* RLC[237] rlc5-rlc9
Rrlc237 rlc5 nrlc237_1 0.918232085405
Lrlc237 nrlc237_1 nrlc237_2 8.49454890505e-09
Crlc237 nrlc237_2 rlc9 1.71387848447e-07
* RLC[239] rlc5-rlc11
Rrlc239 rlc5 nrlc239_1 0.929560401888
Lrlc239 nrlc239_1 nrlc239_2 4.59994554809e-14
Crlc239 nrlc239_2 rlc11 9.31022836779e-10
* RLC[240] rlc5-rlc12
Rrlc240 rlc5 nrlc240_1 25.7749179617
Lrlc240 nrlc240_1 nrlc240_2 1.26065532403e-06
Crlc240 nrlc240_2 rlc12 3.40880197022e-10
* RLC[242] rlc5-rlc14
Rrlc242 rlc5 nrlc242_1 6.3694746972
Lrlc242 nrlc242_1 nrlc242_2 1.77343220673e-06
Crlc242 nrlc242_2 rlc14 4.85696532713e-11
* RLC[243] rlc5-rlc15
Rrlc243 rlc5 nrlc243_1 2376.10433425
Lrlc243 nrlc243_1 nrlc243_2 0.640670870801
Crlc243 nrlc243_2 rlc15 0.000173480940342
* RLC[246] rlc6-rlc8
Rrlc246 rlc6 nrlc246_1 0.103586863824
Lrlc246 nrlc246_1 nrlc246_2 5.5742285066e-05
Crlc246 nrlc246_2 rlc8 6.38591809511e-06
* RLC[250] rlc6-rlc12
Rrlc250 rlc6 nrlc250_1 9.17329655146
Lrlc250 nrlc250_1 nrlc250_2 1.51151469695e-13
Crlc250 nrlc250_2 rlc12 6.48920661954e-11
* RLC[251] rlc6-rlc13
Rrlc251 rlc6 nrlc251_1 0.01
Lrlc251 nrlc251_1 nrlc251_2 2.46537036015e-06
Crlc251 nrlc251_2 rlc13 4.22151121882e-05
* RLC[252] rlc6-rlc14
Rrlc252 rlc6 nrlc252_1 42.4955658732
Lrlc252 nrlc252_1 nrlc252_2 2.60028600268e-06
Crlc252 nrlc252_2 rlc14 3.76839088167e-11
* RLC[253] rlc6-rlc15
Rrlc253 rlc6 nrlc253_1 15.7547557661
Lrlc253 nrlc253_1 nrlc253_2 6.4461230103e-07
Crlc253 nrlc253_2 rlc15 3.02557359676e-11
* RLC[256] rlc7-rlc9
Rrlc256 rlc7 nrlc256_1 6.10596872508
Lrlc256 nrlc256_1 nrlc256_2 1.44784617652e-07
Crlc256 nrlc256_2 rlc9 2.7759939394e-10
* RLC[257] rlc7-rlc10
Rrlc257 rlc7 nrlc257_1 0.0100000054893
Lrlc257 nrlc257_1 nrlc257_2 1.69448320096e-13
Crlc257 nrlc257_2 rlc10 2.17505388689e-10
* RLC[258] rlc7-rlc11
Rrlc258 rlc7 nrlc258_1 20.605522658
Lrlc258 nrlc258_1 nrlc258_2 8.10903457266e-07
Crlc258 nrlc258_2 rlc11 8.08523334494e-11
* RLC[260] rlc7-rlc13
Rrlc260 rlc7 nrlc260_1 60.7300549703
Lrlc260 nrlc260_1 nrlc260_2 4.92511184354e-06
Crlc260 nrlc260_2 rlc13 8.17942630785e-11
* RLC[261] rlc7-rlc14
Rrlc261 rlc7 nrlc261_1 67.3028386286
Lrlc261 nrlc261_1 nrlc261_2 1.0601943948e-05
Crlc261 nrlc261_2 rlc14 5.98628048517e-12
* RLC[262] rlc7-rlc15
Rrlc262 rlc7 nrlc262_1 17.5660498642
Lrlc262 nrlc262_1 nrlc262_2 1.57492739515e-06
Crlc262 nrlc262_2 rlc15 6.88318604694e-12
* RLC[263] rlc7-P1B
Rrlc263 rlc7 nrlc263_1 10.2599034044
Lrlc263 nrlc263_1 nrlc263_2 4.6749542791e-06
Crlc263 nrlc263_2 P1B 9.19694306977e-11
* RLC[264] rlc8-rlc9
Rrlc264 rlc8 nrlc264_1 7.42708060295
Lrlc264 nrlc264_1 nrlc264_2 4.55334730151e-07
Crlc264 nrlc264_2 rlc9 0.000664560540374
* RLC[268] rlc8-rlc13
Rrlc268 rlc8 nrlc268_1 3.7345753269
Lrlc268 nrlc268_1 nrlc268_2 1.92825627777e-09
Crlc268 nrlc268_2 rlc13 4.08142590362e-10
* RLC[269] rlc8-rlc14
Rrlc269 rlc8 nrlc269_1 0.267002757603
Lrlc269 nrlc269_1 nrlc269_2 2.21216908156e-07
Crlc269 nrlc269_2 rlc14 5.73624699611e-09
* RLC[272] rlc9-rlc10
Rrlc272 rlc9 nrlc272_1 42.4307628218
Lrlc272 nrlc272_1 nrlc272_2 1.11680963622e-06
Crlc272 nrlc272_2 rlc10 5.08939453944e-10
* RLC[273] rlc9-rlc11
Rrlc273 rlc9 nrlc273_1 838.279189174
Lrlc273 nrlc273_1 nrlc273_2 1
Crlc273 nrlc273_2 rlc11 0.000378671979244
* RLC[275] rlc9-rlc13
Rrlc275 rlc9 nrlc275_1 0.017736340149
Lrlc275 nrlc275_1 nrlc275_2 2.22992659813e-05
Crlc275 nrlc275_2 rlc13 7.87625992799e-05
* RLC[276] rlc9-rlc14
Rrlc276 rlc9 nrlc276_1 13.6155087558
Lrlc276 nrlc276_1 nrlc276_2 8.08514443455e-07
Crlc276 nrlc276_2 rlc14 5.6405984661e-10
* RLC[277] rlc9-rlc15
Rrlc277 rlc9 nrlc277_1 49.1537375309
Lrlc277 nrlc277_1 nrlc277_2 8.56961337507e-06
Crlc277 nrlc277_2 rlc15 6.18534390331e-12
* RLC[278] rlc9-P1B
Rrlc278 rlc9 nrlc278_1 3.02762603111
Lrlc278 nrlc278_1 nrlc278_2 6.71425936306e-12
Crlc278 nrlc278_2 P1B 3.79026049642e-07
* RLC[280] rlc10-rlc12
Rrlc280 rlc10 nrlc280_1 49.728906108
Lrlc280 nrlc280_1 nrlc280_2 8.25279036814e-06
Crlc280 nrlc280_2 rlc12 3.70800654393e-12
* RLC[282] rlc10-rlc14
Rrlc282 rlc10 nrlc282_1 0.01
Lrlc282 nrlc282_1 nrlc282_2 1.12097001888e-13
Crlc282 nrlc282_2 rlc14 9.20466136112e-11
* RLC[284] rlc10-P1B
Rrlc284 rlc10 nrlc284_1 20.9039585829
Lrlc284 nrlc284_1 nrlc284_2 1.22991421901e-07
Crlc284 nrlc284_2 P1B 1.21963816619e-10
* RLC[286] rlc11-rlc13
Rrlc286 rlc11 nrlc286_1 300.85849381
Lrlc286 nrlc286_1 nrlc286_2 1
Crlc286 nrlc286_2 rlc13 0.000982135788947
* RLC[289] rlc11-P1B
Rrlc289 rlc11 nrlc289_1 0.121282746522
Lrlc289 nrlc289_1 nrlc289_2 1.810136791e-08
Crlc289 nrlc289_2 P1B 1.36732211945e-09
* RLC[292] rlc12-rlc15
Rrlc292 rlc12 nrlc292_1 0.154181948421
Lrlc292 nrlc292_1 nrlc292_2 1.00612305437e-08
Crlc292 nrlc292_2 rlc15 4.71467333553e-10
* RLC[295] rlc13-rlc15
Rrlc295 rlc13 nrlc295_1 138.928788151
Lrlc295 nrlc295_1 nrlc295_2 3.96479099875e-06
Crlc295 nrlc295_2 rlc15 4.61384868573e-11
* RLC[297] rlc14-rlc15
Rrlc297 rlc14 nrlc297_1 2.35207400019
Lrlc297 nrlc297_1 nrlc297_2 1.08590080058e-07
Crlc297 nrlc297_2 rlc15 2.18101966474e-11
* RLC[299] rlc15-P1B
Rrlc299 rlc15 nrlc299_1 0.153670536147
Lrlc299 nrlc299_1 nrlc299_2 2.20935577005e-07
Crlc299 nrlc299_2 P1B 1.75553223031e-07
* DC[0] P1A-P2A
Rdc0 P1A ndc0_1 0.0763488961379
Ldc0 ndc0_1 P2A 6.25106090536e-08
* DC[23] P3A-P4A
Rdc23 P3A ndc23_1 0.0215484753251
Ldc23 ndc23_1 P4A 6.29059741894e-08
* DC[42] P1B-P2B
Rdc42 P1B ndc42_1 1.86481465631
Ldc42 ndc42_1 P2B 2.43966235627e-06
* DC[43] P1B-P3B
Rdc43 P1B ndc43_1 0.879431839485
Ldc43 ndc43_1 P3B 6.91337826108e-07
* DC[44] P1B-P4B
Rdc44 P1B ndc44_1 0.0100071999266
Ldc44 ndc44_1 P4B 7.91412406896e-05
* DC[45] P1B-dc0
Rdc45 P1B ndc45_1 54.3186344205
Ldc45 ndc45_1 dc0 8.64507917003e-06
* DC[46] P1B-dc1
Rdc46 P1B ndc46_1 0.010179167703
Ldc46 ndc46_1 dc1 4.35350794557e-08
* DC[48] P1B-dc3
Rdc48 P1B ndc48_1 0.0108404629798
Ldc48 ndc48_1 dc3 3.40748369606e-05
* DC[50] P2B-P3B
Rdc50 P2B ndc50_1 1157.46148991
Ldc50 ndc50_1 P3B 0.000184457803307
* DC[51] P2B-P4B
Rdc51 P2B ndc51_1 11.0888329014
Ldc51 ndc51_1 P4B 0.000133376274051
* DC[52] P2B-dc0
Rdc52 P2B ndc52_1 1.8120382265
Ldc52 ndc52_1 dc0 1.19730066511e-05
* DC[53] P2B-dc1
Rdc53 P2B ndc53_1 0.0103886532946
Ldc53 ndc53_1 dc1 2.23737860326e-07
* DC[55] P2B-dc3
Rdc55 P2B ndc55_1 13.886186809
Ldc55 ndc55_1 dc3 2.50491834189e-06
* DC[56] P2B-P1B
Rdc56 P2B ndc56_1 0.0238615443732
Ldc56 ndc56_1 P1B 1.3306258656e-07
* DC[57] P3B-P4B
Rdc57 P3B ndc57_1 0.125798688898
Ldc57 ndc57_1 P4B 1.20192758939e-07
* DC[58] P3B-dc0
Rdc58 P3B ndc58_1 1302.22116514
Ldc58 ndc58_1 dc0 0.0519726285692
* DC[61] P3B-dc3
Rdc61 P3B ndc61_1 6.33046106933
Ldc61 ndc61_1 dc3 1.03819936363e-06
* DC[63] P4B-dc0
Rdc63 P4B ndc63_1 0.38207388728
Ldc63 ndc63_1 dc0 1.3112522398e-05
* DC[70] dc0-dc3
Rdc70 dc0 ndc70_1 0.0100030383741
Ldc70 ndc70_1 dc3 0.00206516576157
* DC[71] dc0-P1B
Rdc71 dc0 ndc71_1 54.3186344205
Ldc71 ndc71_1 P1B 8.64507917003e-06
* DC[73] dc1-dc3
Rdc73 dc1 ndc73_1 4.33725046119
Ldc73 ndc73_1 dc3 0.944065854289
* DC[74] dc1-P1B
Rdc74 dc1 ndc74_1 0.0138038139897
Ldc74 ndc74_1 P1B 9.60700616681e-07
* DC[77] dc3-P1B
Rdc77 dc3 ndc77_1 0.01
Ldc77 ndc77_1 P1B 1.4733010263e-05
* ---- leaks
Rleak_P1A P1A P1B 1e+12
Rleak_P2A P2A P1B 1e+12
Rleak_P2B P2B P1B 1e+12
Rleak_P3A P3A P1B 1e+12
Rleak_P3B P3B P1B 1e+12
Rleak_P4A P4A P1B 1e+12
Rleak_P4B P4B P1B 1e+12
Rleak_dc0 dc0 P1B 1e+12
Rleak_dc1 dc1 P1B 1e+12
Rleak_dc3 dc3 P1B 1e+12
Rleak_rlc0 rlc0 P1B 1e+12
Rleak_rlc1 rlc1 P1B 1e+12
Rleak_rlc10 rlc10 P1B 1e+12
Rleak_rlc11 rlc11 P1B 1e+12
Rleak_rlc12 rlc12 P1B 1e+12
Rleak_rlc13 rlc13 P1B 1e+12
Rleak_rlc14 rlc14 P1B 1e+12
Rleak_rlc15 rlc15 P1B 1e+12
Rleak_rlc2 rlc2 P1B 1e+12
Rleak_rlc3 rlc3 P1B 1e+12
Rleak_rlc4 rlc4 P1B 1e+12
Rleak_rlc5 rlc5 P1B 1e+12
Rleak_rlc6 rlc6 P1B 1e+12
Rleak_rlc7 rlc7 P1B 1e+12
Rleak_rlc8 rlc8 P1B 1e+12
Rleak_rlc9 rlc9 P1B 1e+12
.ends fitted
