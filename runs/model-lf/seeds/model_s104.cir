* fitted: 4-port fitted model, reference z0 = 50 Ohm
* port p is PpA (+) to PpB (-); the reference node is P1B
.subckt fitted P1A P1B P2A P2B P3A P3B P4A P4B
* ---- branches
* RLC[0] P1A-P2A
Rrlc0 P1A nrlc0_1 15608.795285
Lrlc0 nrlc0_1 nrlc0_2 1
Crlc0 nrlc0_2 P2A 4.56056574739e-12
* RLC[1] P1A-P3A
Rrlc1 P1A nrlc1_1 696848.46078
Lrlc1 nrlc1_1 nrlc1_2 0.00147626819391
Crlc1 nrlc1_2 P3A 2.02321974498e-14
* RLC[2] P1A-P4A
Rrlc2 P1A nrlc2_1 10418.0976116
Lrlc2 nrlc2_1 nrlc2_2 0.000216902371567
Crlc2 nrlc2_2 P4A 8.26961201894e-15
* RLC[4] P1A-P2B
Rrlc4 P1A nrlc4_1 8607.0089096
Lrlc4 nrlc4_1 nrlc4_2 0.00190979214129
Crlc4 nrlc4_2 P2B 2.8644357635e-14
* RLC[5] P1A-P3B
Rrlc5 P1A nrlc5_1 122070.470888
Lrlc5 nrlc5_1 nrlc5_2 0.000327379746641
Crlc5 nrlc5_2 P3B 2.26025503564e-13
* RLC[6] P1A-P4B
Rrlc6 P1A nrlc6_1 23250.6261503
Lrlc6 nrlc6_1 nrlc6_2 0.00413695137106
Crlc6 nrlc6_2 P4B 8.50292992941e-15
* RLC[7] P1A-rlc0
Rrlc7 P1A nrlc7_1 3698782.87936
Lrlc7 nrlc7_1 nrlc7_2 0.444770614435
Crlc7 nrlc7_2 rlc0 5.75470801694e-14
* RLC[8] P1A-rlc1
Rrlc8 P1A nrlc8_1 0.104274405249
Lrlc8 nrlc8_1 nrlc8_2 9.38996033518e-11
Crlc8 nrlc8_2 rlc1 9.59546013394e-12
* RLC[11] P1A-rlc4
Rrlc11 P1A nrlc11_1 6027.0578417
Lrlc11 nrlc11_1 nrlc11_2 0.00119808559951
Crlc11 nrlc11_2 rlc4 3.66466786476e-14
* RLC[15] P1A-rlc8
Rrlc15 P1A nrlc15_1 994772.14608
Lrlc15 nrlc15_1 nrlc15_2 0.0349729118391
Crlc15 nrlc15_2 rlc8 9.92678378778e-14
* RLC[17] P1A-rlc10
Rrlc17 P1A nrlc17_1 4145.37990286
Lrlc17 nrlc17_1 nrlc17_2 0.000657527082277
Crlc17 nrlc17_2 rlc10 4.25150271439e-14
* RLC[19] P1A-rlc12
Rrlc19 P1A nrlc19_1 270.482052202
Lrlc19 nrlc19_1 nrlc19_2 6.79509489938e-07
Crlc19 nrlc19_2 rlc12 1.66712042467e-12
* RLC[22] P1A-rlc15
Rrlc22 P1A nrlc22_1 1898.06328603
Lrlc22 nrlc22_1 nrlc22_2 0.000211526574256
Crlc22 nrlc22_2 rlc15 6.52380616677e-14
* RLC[24] P2A-P3A
Rrlc24 P2A nrlc24_1 602810125.64
Lrlc24 nrlc24_1 nrlc24_2 1
Crlc24 nrlc24_2 P3A 6.12731768312e-15
* RLC[28] P2A-P3B
Rrlc28 P2A nrlc28_1 84058.3398889
Lrlc28 nrlc28_1 nrlc28_2 0.00150168055828
Crlc28 nrlc28_2 P3B 8.54267778062e-14
* RLC[35] P2A-rlc5
Rrlc35 P2A nrlc35_1 10750.9476744
Lrlc35 nrlc35_1 nrlc35_2 0.00192337038707
Crlc35 nrlc35_2 rlc5 1.84895746128e-14
* RLC[36] P2A-rlc6
Rrlc36 P2A nrlc36_1 130249923631
Lrlc36 nrlc36_1 nrlc36_2 0.933538258216
Crlc36 nrlc36_2 rlc6 3.38302440462e-11
* RLC[38] P2A-rlc8
Rrlc38 P2A nrlc38_1 3747903.47278
Lrlc38 nrlc38_1 nrlc38_2 2.71039427785e-06
Crlc38 nrlc38_2 rlc8 2.16057326708e-13
* RLC[39] P2A-rlc9
Rrlc39 P2A nrlc39_1 3779.62477764
Lrlc39 nrlc39_1 nrlc39_2 0.000536204427599
Crlc39 nrlc39_2 rlc9 4.17052291294e-14
* RLC[43] P2A-rlc13
Rrlc43 P2A nrlc43_1 549182724772
Lrlc43 nrlc43_1 nrlc43_2 8.78090438181e-07
Crlc43 nrlc43_2 rlc13 9.70146497044e-12
* RLC[44] P2A-rlc14
Rrlc44 P2A nrlc44_1 588236738489
Lrlc44 nrlc44_1 nrlc44_2 0.999966647991
Crlc44 nrlc44_2 rlc14 1.11229245548e-11
* RLC[47] P3A-P4A
Rrlc47 P3A nrlc47_1 0.339409995156
Lrlc47 nrlc47_1 nrlc47_2 1.9583085925e-07
Crlc47 nrlc47_2 P4A 6.24584850541e-06
* RLC[51] P3A-P4B
Rrlc51 P3A nrlc51_1 4.61195560242
Lrlc51 nrlc51_1 nrlc51_2 2.01456658483e-07
Crlc51 nrlc51_2 P4B 1.05237102225e-11
* RLC[52] P3A-rlc0
Rrlc52 P3A nrlc52_1 2598.46459047
Lrlc52 nrlc52_1 nrlc52_2 0.00051223268913
Crlc52 nrlc52_2 rlc0 8.42929348168e-14
* RLC[53] P3A-rlc1
Rrlc53 P3A nrlc53_1 4996.77740829
Lrlc53 nrlc53_1 nrlc53_2 0.000781764555784
Crlc53 nrlc53_2 rlc1 3.47899224025e-14
* RLC[56] P3A-rlc4
Rrlc56 P3A nrlc56_1 35.626339308
Lrlc56 nrlc56_1 nrlc56_2 1.56644614066e-06
Crlc56 nrlc56_2 rlc4 1.37129394366e-12
* RLC[58] P3A-rlc6
Rrlc58 P3A nrlc58_1 997.59695165
Lrlc58 nrlc58_1 nrlc58_2 9.74400251218e-05
Crlc58 nrlc58_2 rlc6 1.08788916415e-13
* RLC[59] P3A-rlc7
Rrlc59 P3A nrlc59_1 139.418695692
Lrlc59 nrlc59_1 nrlc59_2 6.12435366922e-06
Crlc59 nrlc59_2 rlc7 3.50086788732e-13
* RLC[60] P3A-rlc8
Rrlc60 P3A nrlc60_1 5562.82361135
Lrlc60 nrlc60_1 nrlc60_2 0.00141049168426
Crlc60 nrlc60_2 rlc8 5.06451010423e-14
* RLC[61] P3A-rlc9
Rrlc61 P3A nrlc61_1 8971.65889228
Lrlc61 nrlc61_1 nrlc61_2 0.0025192303083
Crlc61 nrlc61_2 rlc9 3.47760183972e-14
* RLC[66] P3A-rlc14
Rrlc66 P3A nrlc66_1 2353.62175619
Lrlc66 nrlc66_1 nrlc66_2 0.000415183026077
Crlc66 nrlc66_2 rlc14 8.32767448002e-14
* RLC[67] P3A-rlc15
Rrlc67 P3A nrlc67_1 3065.66839678
Lrlc67 nrlc67_1 nrlc67_2 0.000489646667493
Crlc67 nrlc67_2 rlc15 5.78881859067e-14
* RLC[69] P4A-P1B
Rrlc69 P4A nrlc69_1 25440.579581
Lrlc69 nrlc69_1 nrlc69_2 0.00242572817173
Crlc69 nrlc69_2 P1B 1.36795626027e-14
* RLC[70] P4A-P2B
Rrlc70 P4A nrlc70_1 3270072.99031
Lrlc70 nrlc70_1 nrlc70_2 7.89725345108e-07
Crlc70 nrlc70_2 P2B 3.10438687307e-13
* RLC[71] P4A-P3B
Rrlc71 P4A nrlc71_1 10461.2670954
Lrlc71 nrlc71_1 nrlc71_2 0.00327367873707
Crlc71 nrlc71_2 P3B 3.32372410686e-14
* RLC[73] P4A-rlc0
Rrlc73 P4A nrlc73_1 15818.0365367
Lrlc73 nrlc73_1 nrlc73_2 0.00444035997465
Crlc73 nrlc73_2 rlc0 1.97183477339e-14
* RLC[75] P4A-rlc2
Rrlc75 P4A nrlc75_1 25997.0315017
Lrlc75 nrlc75_1 nrlc75_2 0.0120899578483
Crlc75 nrlc75_2 rlc2 1.98762639956e-14
* RLC[76] P4A-rlc3
Rrlc76 P4A nrlc76_1 436969.330055
Lrlc76 nrlc76_1 nrlc76_2 0.00629949591364
Crlc76 nrlc76_2 rlc3 3.5917579867e-13
* RLC[77] P4A-rlc4
Rrlc77 P4A nrlc77_1 27540.3038129
Lrlc77 nrlc77_1 nrlc77_2 0.000199687414363
Crlc77 nrlc77_2 rlc4 6.78965246418e-13
* RLC[78] P4A-rlc5
Rrlc78 P4A nrlc78_1 971.880805837
Lrlc78 nrlc78_1 nrlc78_2 4.68651977597e-05
Crlc78 nrlc78_2 rlc5 5.51292309739e-14
* RLC[82] P4A-rlc9
Rrlc82 P4A nrlc82_1 4811.41464273
Lrlc82 nrlc82_1 nrlc82_2 0.000771565800764
Crlc82 nrlc82_2 rlc9 3.70326583865e-14
* RLC[83] P4A-rlc10
Rrlc83 P4A nrlc83_1 139.732722031
Lrlc83 nrlc83_1 nrlc83_2 6.72075416885e-06
Crlc83 nrlc83_2 rlc10 3.82454048064e-13
* RLC[84] P4A-rlc11
Rrlc84 P4A nrlc84_1 127015286387
Lrlc84 nrlc84_1 nrlc84_2 0.996984611465
Crlc84 nrlc84_2 rlc11 1.85502047045e-11
* RLC[85] P4A-rlc12
Rrlc85 P4A nrlc85_1 11.3862680509
Lrlc85 nrlc85_1 nrlc85_2 4.73318149516e-07
Crlc85 nrlc85_2 rlc12 4.05646601043e-12
* RLC[86] P4A-rlc13
Rrlc86 P4A nrlc86_1 1638.60134262
Lrlc86 nrlc86_1 nrlc86_2 0.000230042401
Crlc86 nrlc86_2 rlc13 9.51960151808e-14
* RLC[87] P4A-rlc14
Rrlc87 P4A nrlc87_1 1212.86964568
Lrlc87 nrlc87_1 nrlc87_2 0.000151707664136
Crlc87 nrlc87_2 rlc14 1.14587371609e-13
* RLC[90] P1B-P2B
Rrlc90 P1B nrlc90_1 0.207007557632
Lrlc90 nrlc90_1 nrlc90_2 6.69401853614e-06
Crlc90 nrlc90_2 P2B 0.001
* RLC[91] P1B-P3B
Rrlc91 P1B nrlc91_1 197.918941223
Lrlc91 nrlc91_1 nrlc91_2 7.01195223686e-06
Crlc91 nrlc91_2 P3B 8.93862215958e-11
* RLC[93] P1B-rlc0
Rrlc93 P1B nrlc93_1 0.493837803567
Lrlc93 nrlc93_1 nrlc93_2 1.20221271339e-07
Crlc93 nrlc93_2 rlc0 1.04372324794e-09
* RLC[98] P1B-rlc5
Rrlc98 P1B nrlc98_1 49.1511842398
Lrlc98 nrlc98_1 nrlc98_2 5.18817415038e-06
Crlc98 nrlc98_2 rlc5 5.89938374875e-11
* RLC[100] P1B-rlc7
Rrlc100 P1B nrlc100_1 0.01
Lrlc100 nrlc100_1 nrlc100_2 1.8855286162e-09
Crlc100 nrlc100_2 rlc7 8.83486661322e-07
* RLC[103] P1B-rlc10
Rrlc103 P1B nrlc103_1 0.0199123907032
Lrlc103 nrlc103_1 nrlc103_2 3.97582088171e-07
Crlc103 nrlc103_2 rlc10 0.000882577283963
* RLC[106] P1B-rlc13
Rrlc106 P1B nrlc106_1 134.925591806
Lrlc106 nrlc106_1 nrlc106_2 2.77072332633e-05
Crlc106 nrlc106_2 rlc13 6.0484418235e-07
* RLC[111] P2B-P4B
Rrlc111 P2B nrlc111_1 160.079839931
Lrlc111 nrlc111_1 nrlc111_2 1.06867051958e-05
Crlc111 nrlc111_2 P4B 4.50205830348e-11
* RLC[114] P2B-rlc2
Rrlc114 P2B nrlc114_1 21.58289428
Lrlc114 nrlc114_1 nrlc114_2 7.43154224561e-07
Crlc114 nrlc114_2 rlc2 3.63855237e-09
* RLC[115] P2B-rlc3
Rrlc115 P2B nrlc115_1 4.88955762742
Lrlc115 nrlc115_1 nrlc115_2 3.2569335496e-07
Crlc115 nrlc115_2 rlc3 1.51365622187e-11
* RLC[116] P2B-rlc4
Rrlc116 P2B nrlc116_1 0.0574295317665
Lrlc116 nrlc116_1 nrlc116_2 8.03718675909e-08
Crlc116 nrlc116_2 rlc4 5.8753122652e-06
* RLC[121] P2B-rlc9
Rrlc121 P2B nrlc121_1 0.428100399525
Lrlc121 nrlc121_1 nrlc121_2 0.0659950935289
Crlc121 nrlc121_2 rlc9 0.000400108587736
* RLC[122] P2B-rlc10
Rrlc122 P2B nrlc122_1 79.4020153772
Lrlc122 nrlc122_1 nrlc122_2 1.66121285265e-06
Crlc122 nrlc122_2 rlc10 3.50570488639e-11
* RLC[123] P2B-rlc11
Rrlc123 P2B nrlc123_1 117.837324345
Lrlc123 nrlc123_1 nrlc123_2 3.24294065014e-06
Crlc123 nrlc123_2 rlc11 5.76924062423e-10
* RLC[125] P2B-rlc13
Rrlc125 P2B nrlc125_1 131.21324042
Lrlc125 nrlc125_1 nrlc125_2 3.99831700631e-06
Crlc125 nrlc125_2 rlc13 7.04899103895e-11
* RLC[127] P2B-rlc15
Rrlc127 P2B nrlc127_1 127.690766344
Lrlc127 nrlc127_1 nrlc127_2 4.63280618973e-05
Crlc127 nrlc127_2 rlc15 3.15705854716e-12
* RLC[128] P2B-P1B
Rrlc128 P2B nrlc128_1 0.207519742136
Lrlc128 nrlc128_1 nrlc128_2 1.003092789e-07
Crlc128 nrlc128_2 P1B 1.35146406802e-05
* RLC[131] P3B-rlc1
Rrlc131 P3B nrlc131_1 584.371407228
Lrlc131 nrlc131_1 nrlc131_2 4.68234027786e-05
Crlc131 nrlc131_2 rlc1 5.48205482592e-12
* RLC[134] P3B-rlc4
Rrlc134 P3B nrlc134_1 462.840464781
Lrlc134 nrlc134_1 nrlc134_2 1.76231507692e-05
Crlc134 nrlc134_2 rlc4 6.27663749943e-12
* RLC[135] P3B-rlc5
Rrlc135 P3B nrlc135_1 9.5664682163
Lrlc135 nrlc135_1 nrlc135_2 5.05581989428e-07
Crlc135 nrlc135_2 rlc5 5.05269710315e-08
* RLC[138] P3B-rlc8
Rrlc138 P3B nrlc138_1 0.0104881470902
Lrlc138 nrlc138_1 nrlc138_2 1.55939567016e-07
Crlc138 nrlc138_2 rlc8 0.001
* RLC[139] P3B-rlc9
Rrlc139 P3B nrlc139_1 249.940602318
Lrlc139 nrlc139_1 nrlc139_2 1.07213997015e-06
Crlc139 nrlc139_2 rlc9 4.55974674351e-10
* RLC[142] P3B-rlc12
Rrlc142 P3B nrlc142_1 201.595307845
Lrlc142 nrlc142_1 nrlc142_2 0.246597213827
Crlc142 nrlc142_2 rlc12 0.000367760067972
* RLC[144] P3B-rlc14
Rrlc144 P3B nrlc144_1 459.693959071
Lrlc144 nrlc144_1 nrlc144_2 1.72382014809e-05
Crlc144 nrlc144_2 rlc14 2.89190874309e-12
* RLC[147] P4B-rlc0
Rrlc147 P4B nrlc147_1 34.3239038442
Lrlc147 nrlc147_1 nrlc147_2 1.50999901927e-07
Crlc147 nrlc147_2 rlc0 7.53583085613e-10
* RLC[148] P4B-rlc1
Rrlc148 P4B nrlc148_1 13.7106120408
Lrlc148 nrlc148_1 nrlc148_2 2.92916039732e-07
Crlc148 nrlc148_2 rlc1 2.71012525484e-09
* RLC[149] P4B-rlc2
Rrlc149 P4B nrlc149_1 2.51664382755
Lrlc149 nrlc149_1 nrlc149_2 2.28118924996e-07
Crlc149 nrlc149_2 rlc2 1.95917924887e-06
* RLC[150] P4B-rlc3
Rrlc150 P4B nrlc150_1 31.9792461435
Lrlc150 nrlc150_1 nrlc150_2 3.73839903621e-07
Crlc150 nrlc150_2 rlc3 2.19792039393e-11
* RLC[151] P4B-rlc4
Rrlc151 P4B nrlc151_1 60.8317662564
Lrlc151 nrlc151_1 nrlc151_2 1.54199820509e-05
Crlc151 nrlc151_2 rlc4 4.62999482809e-12
* RLC[152] P4B-rlc5
Rrlc152 P4B nrlc152_1 0.660283648817
Lrlc152 nrlc152_1 nrlc152_2 1.8316141922e-08
Crlc152 nrlc152_2 rlc5 1.67028335458e-05
* RLC[153] P4B-rlc6
Rrlc153 P4B nrlc153_1 61.6857906323
Lrlc153 nrlc153_1 nrlc153_2 0.368040402532
Crlc153 nrlc153_2 rlc6 0.001
* RLC[154] P4B-rlc7
Rrlc154 P4B nrlc154_1 5.82287359606
Lrlc154 nrlc154_1 nrlc154_2 5.75178597212e-08
Crlc154 nrlc154_2 rlc7 2.33446420739e-09
* RLC[155] P4B-rlc8
Rrlc155 P4B nrlc155_1 8994.27094556
Lrlc155 nrlc155_1 nrlc155_2 1
Crlc155 nrlc155_2 rlc8 0.001
* RLC[157] P4B-rlc10
Rrlc157 P4B nrlc157_1 26.9914265013
Lrlc157 nrlc157_1 nrlc157_2 6.85424265955e-07
Crlc157 nrlc157_2 rlc10 6.23431963156e-10
* RLC[162] P4B-rlc15
Rrlc162 P4B nrlc162_1 729.088340285
Lrlc162 nrlc162_1 nrlc162_2 0.0270372409701
Crlc162 nrlc162_2 rlc15 0.000285590554167
* RLC[163] P4B-P1B
Rrlc163 P4B nrlc163_1 1.86966062222
Lrlc163 nrlc163_1 nrlc163_2 1.76506274768e-07
Crlc163 nrlc163_2 P1B 1.31243849303e-06
* RLC[165] rlc0-rlc2
Rrlc165 rlc0 nrlc165_1 9.18764625506
Lrlc165 nrlc165_1 nrlc165_2 3.84019959184e-06
Crlc165 nrlc165_2 rlc2 5.05478579793e-11
* RLC[166] rlc0-rlc3
Rrlc166 rlc0 nrlc166_1 0.161781389008
Lrlc166 nrlc166_1 nrlc166_2 6.31630156653e-09
Crlc166 nrlc166_2 rlc3 9.10099261793e-07
* RLC[167] rlc0-rlc4
Rrlc167 rlc0 nrlc167_1 26.3958349749
Lrlc167 nrlc167_1 nrlc167_2 1.42617737538e-06
Crlc167 nrlc167_2 rlc4 1.46519961112e-10
* RLC[171] rlc0-rlc8
Rrlc171 rlc0 nrlc171_1 0.567479792796
Lrlc171 nrlc171_1 nrlc171_2 2.11492338806e-08
Crlc171 nrlc171_2 rlc8 7.2971172996e-11
* RLC[172] rlc0-rlc9
Rrlc172 rlc0 nrlc172_1 16.2352972918
Lrlc172 nrlc172_1 nrlc172_2 9.00173493537e-08
Crlc172 nrlc172_2 rlc9 1.28043682614e-09
* RLC[173] rlc0-rlc10
Rrlc173 rlc0 nrlc173_1 351.348879293
Lrlc173 nrlc173_1 nrlc173_2 0.000244414431411
Crlc173 nrlc173_2 rlc10 2.39239966847e-08
* RLC[174] rlc0-rlc11
Rrlc174 rlc0 nrlc174_1 90.5958503208
Lrlc174 nrlc174_1 nrlc174_2 9.54190637215e-06
Crlc174 nrlc174_2 rlc11 1.2917427426e-12
* RLC[177] rlc0-rlc14
Rrlc177 rlc0 nrlc177_1 12.5466259053
Lrlc177 nrlc177_1 nrlc177_2 6.89874405177e-07
Crlc177 nrlc177_2 rlc14 6.37641501263e-11
* RLC[178] rlc0-rlc15
Rrlc178 rlc0 nrlc178_1 281.5286195
Lrlc178 nrlc178_1 nrlc178_2 0.0036818140529
Crlc178 nrlc178_2 rlc15 2.79911434411e-06
* RLC[179] rlc0-P1B
Rrlc179 rlc0 nrlc179_1 4.2109876675
Lrlc179 nrlc179_1 nrlc179_2 1.58006154603e-07
Crlc179 nrlc179_2 P1B 4.0416110673e-10
* RLC[181] rlc1-rlc3
Rrlc181 rlc1 nrlc181_1 0.759742972012
Lrlc181 nrlc181_1 nrlc181_2 1.73163711753e-07
Crlc181 nrlc181_2 rlc3 3.33335059448e-10
* RLC[182] rlc1-rlc4
Rrlc182 rlc1 nrlc182_1 6.65025182571
Lrlc182 nrlc182_1 nrlc182_2 9.01387575567e-07
Crlc182 nrlc182_2 rlc4 3.50435556386e-11
* RLC[184] rlc1-rlc6
Rrlc184 rlc1 nrlc184_1 13.124188842
Lrlc184 nrlc184_1 nrlc184_2 4.81200230888e-07
Crlc184 nrlc184_2 rlc6 3.30329610177e-10
* RLC[185] rlc1-rlc7
Rrlc185 rlc1 nrlc185_1 98.6476673903
Lrlc185 nrlc185_1 nrlc185_2 1.25431853387e-08
Crlc185 nrlc185_2 rlc7 1.42298065477e-11
* RLC[190] rlc1-rlc12
Rrlc190 rlc1 nrlc190_1 1.46185246793
Lrlc190 nrlc190_1 nrlc190_2 2.82370505893e-07
Crlc190 nrlc190_2 rlc12 8.22041693823e-06
* RLC[191] rlc1-rlc13
Rrlc191 rlc1 nrlc191_1 498.910811792
Lrlc191 nrlc191_1 nrlc191_2 0.00432106836534
Crlc191 nrlc191_2 rlc13 8.95648689891e-08
* RLC[192] rlc1-rlc14
Rrlc192 rlc1 nrlc192_1 91.3215993349
Lrlc192 nrlc192_1 nrlc192_2 1.93120809911e-05
Crlc192 nrlc192_2 rlc14 3.82116155878e-12
* RLC[194] rlc1-P1B
Rrlc194 rlc1 nrlc194_1 114.600482794
Lrlc194 nrlc194_1 nrlc194_2 5.34527170331e-06
Crlc194 nrlc194_2 P1B 7.59453500994e-12
* RLC[199] rlc2-rlc7
Rrlc199 rlc2 nrlc199_1 0.01
Lrlc199 nrlc199_1 nrlc199_2 9.89708317427e-13
Crlc199 nrlc199_2 rlc7 6.6937411161e-09
* RLC[202] rlc2-rlc10
Rrlc202 rlc2 nrlc202_1 0.122826764121
Lrlc202 nrlc202_1 nrlc202_2 1.10540381307e-06
Crlc202 nrlc202_2 rlc10 4.49578348721e-06
* RLC[205] rlc2-rlc13
Rrlc205 rlc2 nrlc205_1 1.41012619861
Lrlc205 nrlc205_1 nrlc205_2 1.0108085092e-07
Crlc205 nrlc205_2 rlc13 5.64820455933e-11
* RLC[208] rlc2-P1B
Rrlc208 rlc2 nrlc208_1 6.35314379213
Lrlc208 nrlc208_1 nrlc208_2 1.13451922606e-07
Crlc208 nrlc208_2 P1B 8.14738202891e-09
* RLC[210] rlc3-rlc5
Rrlc210 rlc3 nrlc210_1 12.7054272766
Lrlc210 nrlc210_1 nrlc210_2 1.93161015213e-06
Crlc210 nrlc210_2 rlc5 1.32953085431e-11
* RLC[211] rlc3-rlc6
Rrlc211 rlc3 nrlc211_1 218.27347205
Lrlc211 nrlc211_1 nrlc211_2 0.0781358239044
Crlc211 nrlc211_2 rlc6 1.82224082806e-09
* RLC[213] rlc3-rlc8
Rrlc213 rlc3 nrlc213_1 111.534462075
Lrlc213 nrlc213_1 nrlc213_2 1.51264978173e-05
Crlc213 nrlc213_2 rlc8 1.35106961047e-12
* RLC[215] rlc3-rlc10
Rrlc215 rlc3 nrlc215_1 8.31417418706
Lrlc215 nrlc215_1 nrlc215_2 7.44923521743e-07
Crlc215 nrlc215_2 rlc10 1.19737707906e-11
* RLC[216] rlc3-rlc11
Rrlc216 rlc3 nrlc216_1 121.137092627
Lrlc216 nrlc216_1 nrlc216_2 0.000232426496875
Crlc216 nrlc216_2 rlc11 1.26770857116e-07
* RLC[217] rlc3-rlc12
Rrlc217 rlc3 nrlc217_1 29.6178505212
Lrlc217 nrlc217_1 nrlc217_2 0.198460702521
Crlc217 nrlc217_2 rlc12 0.000367540786929
* RLC[219] rlc3-rlc14
Rrlc219 rlc3 nrlc219_1 6.11320302996
Lrlc219 nrlc219_1 nrlc219_2 8.3222655618e-07
Crlc219 nrlc219_2 rlc14 6.26154356941e-11
* RLC[221] rlc3-P1B
Rrlc221 rlc3 nrlc221_1 0.01
Lrlc221 nrlc221_1 nrlc221_2 6.38403940855e-14
Crlc221 nrlc221_2 P1B 3.31092397404e-10
* RLC[224] rlc4-rlc7
Rrlc224 rlc4 nrlc224_1 1.2089737493
Lrlc224 nrlc224_1 nrlc224_2 5.39964780371e-08
Crlc224 nrlc224_2 rlc7 2.4744026378e-06
* RLC[225] rlc4-rlc8
Rrlc225 rlc4 nrlc225_1 152.895124733
Lrlc225 nrlc225_1 nrlc225_2 2.73483078512e-06
Crlc225 nrlc225_2 rlc8 7.79193832793e-12
* RLC[227] rlc4-rlc10
Rrlc227 rlc4 nrlc227_1 1.65614144748
Lrlc227 nrlc227_1 nrlc227_2 1.90590010692e-06
Crlc227 nrlc227_2 rlc10 2.3315629844e-06
* RLC[230] rlc4-rlc13
Rrlc230 rlc4 nrlc230_1 0.01
Lrlc230 nrlc230_1 nrlc230_2 5.20565823242e-14
Crlc230 nrlc230_2 rlc13 2.35715527366e-10
* RLC[231] rlc4-rlc14
Rrlc231 rlc4 nrlc231_1 4.54208398261
Lrlc231 nrlc231_1 nrlc231_2 2.18683578973e-07
Crlc231 nrlc231_2 rlc14 5.51638527271e-10
* RLC[234] rlc5-rlc6
Rrlc234 rlc5 nrlc234_1 0.97633103705
Lrlc234 nrlc234_1 nrlc234_2 1.8594772277e-07
Crlc234 nrlc234_2 rlc6 2.16747611902e-10
* RLC[236] rlc5-rlc8
Rrlc236 rlc5 nrlc236_1 0.0117540964987
Lrlc236 nrlc236_1 nrlc236_2 2.32196962499e-08
Crlc236 nrlc236_2 rlc8 4.77436666985e-05
* RLC[239] rlc5-rlc11
Rrlc239 rlc5 nrlc239_1 2.17767155422
Lrlc239 nrlc239_1 nrlc239_2 1.63624929569e-07
Crlc239 nrlc239_2 rlc11 3.83373603303e-11
* RLC[241] rlc5-rlc13
Rrlc241 rlc5 nrlc241_1 1.86959635422
Lrlc241 nrlc241_1 nrlc241_2 9.91751260912e-08
Crlc241 nrlc241_2 rlc13 4.39412283969e-10
* RLC[244] rlc5-P1B
Rrlc244 rlc5 nrlc244_1 240.406892689
Lrlc244 nrlc244_1 nrlc244_2 3.42666336172e-05
Crlc244 nrlc244_2 P1B 1.65905383398e-11
* RLC[247] rlc6-rlc9
Rrlc247 rlc6 nrlc247_1 0.0235124394839
Lrlc247 nrlc247_1 nrlc247_2 0.000497551329435
Crlc247 nrlc247_2 rlc9 0.001
* RLC[248] rlc6-rlc10
Rrlc248 rlc6 nrlc248_1 98.3653498616
Lrlc248 nrlc248_1 nrlc248_2 4.42539467366e-05
Crlc248 nrlc248_2 rlc10 7.12798428399e-12
* RLC[249] rlc6-rlc11
Rrlc249 rlc6 nrlc249_1 397.879197419
Lrlc249 nrlc249_1 nrlc249_2 1
Crlc249 nrlc249_2 rlc11 0.001
* RLC[253] rlc6-rlc15
Rrlc253 rlc6 nrlc253_1 0.681768959595
Lrlc253 nrlc253_1 nrlc253_2 5.06594808439e-07
Crlc253 nrlc253_2 rlc15 1.21099897874e-09
* RLC[254] rlc6-P1B
Rrlc254 rlc6 nrlc254_1 12.3007072227
Lrlc254 nrlc254_1 nrlc254_2 3.10917128033e-06
Crlc254 nrlc254_2 P1B 2.28318958709e-11
* RLC[256] rlc7-rlc9
Rrlc256 rlc7 nrlc256_1 55.1642823034
Lrlc256 nrlc256_1 nrlc256_2 1.67713025172e-06
Crlc256 nrlc256_2 rlc9 1.88580991822e-09
* RLC[257] rlc7-rlc10
Rrlc257 rlc7 nrlc257_1 3.96433198414
Lrlc257 nrlc257_1 nrlc257_2 1.1634286932e-06
Crlc257 nrlc257_2 rlc10 8.22540381564e-11
* RLC[259] rlc7-rlc12
Rrlc259 rlc7 nrlc259_1 21.0798938118
Lrlc259 nrlc259_1 nrlc259_2 8.65116159531e-07
Crlc259 nrlc259_2 rlc12 2.44673926953e-10
* RLC[261] rlc7-rlc14
Rrlc261 rlc7 nrlc261_1 57.0047511516
Lrlc261 nrlc261_1 nrlc261_2 7.78218224642e-06
Crlc261 nrlc261_2 rlc14 5.50065630018e-12
* RLC[264] rlc8-rlc9
Rrlc264 rlc8 nrlc264_1 1.21323981137
Lrlc264 nrlc264_1 nrlc264_2 3.23054971746e-08
Crlc264 nrlc264_2 rlc9 6.52452116493e-11
* RLC[265] rlc8-rlc10
Rrlc265 rlc8 nrlc265_1 0.0116055037007
Lrlc265 nrlc265_1 nrlc265_2 2.00578263396e-07
Crlc265 nrlc265_2 rlc10 0.000431877703368
* RLC[266] rlc8-rlc11
Rrlc266 rlc8 nrlc266_1 278.623303336
Lrlc266 nrlc266_1 nrlc266_2 1.86779279763e-05
Crlc266 nrlc266_2 rlc11 2.63230763472e-09
* RLC[271] rlc8-P1B
Rrlc271 rlc8 nrlc271_1 13.0225824626
Lrlc271 nrlc271_1 nrlc271_2 6.16824543272e-07
Crlc271 nrlc271_2 P1B 2.26296099254e-10
* RLC[273] rlc9-rlc11
Rrlc273 rlc9 nrlc273_1 4.47760886994
Lrlc273 nrlc273_1 nrlc273_2 5.32465990164e-07
Crlc273 nrlc273_2 rlc11 2.29003227416e-07
* RLC[274] rlc9-rlc12
Rrlc274 rlc9 nrlc274_1 0.0914043032187
Lrlc274 nrlc274_1 nrlc274_2 3.48952497428e-07
Crlc274 nrlc274_2 rlc12 7.49454037578e-08
* RLC[275] rlc9-rlc13
Rrlc275 rlc9 nrlc275_1 0.01
Lrlc275 nrlc275_1 nrlc275_2 5.46551460447e-14
Crlc275 nrlc275_2 rlc13 2.7289983037e-10
* RLC[277] rlc9-rlc15
Rrlc277 rlc9 nrlc277_1 10.7551676886
Lrlc277 nrlc277_1 nrlc277_2 2.1369767558e-06
Crlc277 nrlc277_2 rlc15 2.05268787388e-11
* RLC[280] rlc10-rlc12
Rrlc280 rlc10 nrlc280_1 33.5498264656
Lrlc280 nrlc280_1 nrlc280_2 2.88455437798e-06
Crlc280 nrlc280_2 rlc12 1.83910068006e-11
* RLC[281] rlc10-rlc13
Rrlc281 rlc10 nrlc281_1 4.87694409347
Lrlc281 nrlc281_1 nrlc281_2 1.41125056485e-07
Crlc281 nrlc281_2 rlc13 4.46850495094e-10
* RLC[282] rlc10-rlc14
Rrlc282 rlc10 nrlc282_1 6.22679746544
Lrlc282 nrlc282_1 nrlc282_2 7.69462258667e-09
Crlc282 nrlc282_2 rlc14 6.1226805856e-10
* RLC[283] rlc10-rlc15
Rrlc283 rlc10 nrlc283_1 1.26453771334
Lrlc283 nrlc283_1 nrlc283_2 5.86883182177e-08
Crlc283 nrlc283_2 rlc15 4.07798461189e-11
* RLC[284] rlc10-P1B
Rrlc284 rlc10 nrlc284_1 18.5248155609
Lrlc284 nrlc284_1 nrlc284_2 8.51680777105e-06
Crlc284 nrlc284_2 P1B 2.75757002916e-11
* RLC[286] rlc11-rlc13
Rrlc286 rlc11 nrlc286_1 36.2539687133
Lrlc286 nrlc286_1 nrlc286_2 3.28221221237e-06
Crlc286 nrlc286_2 rlc13 2.77468084723e-12
* RLC[288] rlc11-rlc15
Rrlc288 rlc11 nrlc288_1 165.899009979
Lrlc288 nrlc288_1 nrlc288_2 3.90959216e-05
Crlc288 nrlc288_2 rlc15 1.49912473777e-08
* RLC[289] rlc11-P1B
Rrlc289 rlc11 nrlc289_1 13908.6317793
Lrlc289 nrlc289_1 nrlc289_2 0.147400865053
Crlc289 nrlc289_2 P1B 0.001
* RLC[290] rlc12-rlc13
Rrlc290 rlc12 nrlc290_1 794.346394256
Lrlc290 nrlc290_1 nrlc290_2 0.0265620232502
Crlc290 nrlc290_2 rlc13 0.001
* RLC[294] rlc13-rlc14
Rrlc294 rlc13 nrlc294_1 270.44635009
Lrlc294 nrlc294_1 nrlc294_2 0.116485404465
Crlc294 nrlc294_2 rlc14 1.76956595113e-09
* RLC[296] rlc13-P1B
Rrlc296 rlc13 nrlc296_1 1.42243733013
Lrlc296 nrlc296_1 nrlc296_2 2.9152130255e-07
Crlc296 nrlc296_2 P1B 4.4287055929e-10
* RLC[297] rlc14-rlc15
Rrlc297 rlc14 nrlc297_1 27.4183300278
Lrlc297 nrlc297_1 nrlc297_2 1.5016305167e-06
Crlc297 nrlc297_2 rlc15 5.34584058642e-11
* RLC[298] rlc14-P1B
Rrlc298 rlc14 nrlc298_1 19.9844680713
Lrlc298 nrlc298_1 nrlc298_2 1.96223108612e-06
Crlc298 nrlc298_2 P1B 2.6315897342e-11
* DC[0] P1A-P2A
Rdc0 P1A ndc0_1 0.0568027389557
Ldc0 ndc0_1 P2A 7.05954915049e-08
* DC[23] P3A-P4A
Rdc23 P3A ndc23_1 0.119872104348
Ldc23 ndc23_1 P4A 1.78081474676e-07
* DC[42] P1B-P2B
Rdc42 P1B ndc42_1 0.470881226048
Ldc42 ndc42_1 P2B 7.67642858471e-05
* DC[43] P1B-P3B
Rdc43 P1B ndc43_1 151.300138293
Ldc43 ndc43_1 P3B 0.000144769714793
* DC[45] P1B-dc0
Rdc45 P1B ndc45_1 0.451556098814
Ldc45 ndc45_1 dc0 2.26276083909e-06
* DC[47] P1B-dc2
Rdc47 P1B ndc47_1 19.8065555648
Ldc47 ndc47_1 dc2 8.16544457199e-05
* DC[50] P2B-P3B
Rdc50 P2B ndc50_1 1066.48611866
Ldc50 ndc50_1 P3B 0.000169736537523
* DC[51] P2B-P4B
Rdc51 P2B ndc51_1 1.30812373252
Ldc51 ndc51_1 P4B 2.54644916522e-06
* DC[52] P2B-dc0
Rdc52 P2B ndc52_1 0.0214035099992
Ldc52 ndc52_1 dc0 1.43394395296e-08
* DC[53] P2B-dc1
Rdc53 P2B ndc53_1 0.010611508637
Ldc53 ndc53_1 dc1 0.000305773055926
* DC[54] P2B-dc2
Rdc54 P2B ndc54_1 0.0100651896362
Ldc54 ndc54_1 dc2 0.000130997047183
* DC[55] P2B-dc3
Rdc55 P2B ndc55_1 0.0337831121507
Ldc55 ndc55_1 dc3 3.46314587273e-07
* DC[56] P2B-P1B
Rdc56 P2B ndc56_1 0.173232136414
Ldc56 ndc56_1 P1B 2.82790259172e-05
* DC[57] P3B-P4B
Rdc57 P3B ndc57_1 0.0105863917842
Ldc57 ndc57_1 P4B 1.07327320748e-07
* DC[59] P3B-dc1
Rdc59 P3B ndc59_1 0.0151161381196
Ldc59 ndc59_1 dc1 9.17842769576e-06
* DC[60] P3B-dc2
Rdc60 P3B ndc60_1 0.0115202456479
Ldc60 ndc60_1 dc2 1.5998233824e-08
* DC[61] P3B-dc3
Rdc61 P3B ndc61_1 0.790092311246
Ldc61 ndc61_1 dc3 5.54781658781e-07
* DC[62] P3B-P1B
Rdc62 P3B ndc62_1 22.9739668038
Ldc62 ndc62_1 P1B 2.19824146012e-05
* DC[63] P4B-dc0
Rdc63 P4B ndc63_1 136.012773772
Ldc63 ndc63_1 dc0 1
* DC[65] P4B-dc2
Rdc65 P4B ndc65_1 17.3678649166
Ldc65 ndc65_1 dc2 1.3683893013e-05
* DC[66] P4B-dc3
Rdc66 P4B ndc66_1 0.198472027021
Ldc66 ndc66_1 dc3 5.25145208738e-08
* DC[68] dc0-dc1
Rdc68 dc0 ndc68_1 12.0945415293
Ldc68 ndc68_1 dc1 1.92490606882e-06
* DC[71] dc0-P1B
Rdc71 dc0 ndc71_1 0.0178109346804
Ldc71 ndc71_1 P1B 7.16069825713e-08
* DC[72] dc1-dc2
Rdc72 dc1 ndc72_1 0.0395345303449
Ldc72 ndc72_1 dc2 6.2921159272e-09
* DC[75] dc2-dc3
Rdc75 dc2 ndc75_1 0.0100688746302
Ldc75 ndc75_1 dc3 0.000290826777367
* DC[76] dc2-P1B
Rdc76 dc2 ndc76_1 2.53233549085
Ldc76 ndc76_1 P1B 1.0439833592e-05
* ---- leaks
Rleak_P1A P1A P1B 1e+12
Rleak_P2A P2A P1B 1e+12
Rleak_P2B P2B P1B 1e+12
Rleak_P3A P3A P1B 1e+12
Rleak_P3B P3B P1B 1e+12
Rleak_P4A P4A P1B 1e+12
Rleak_P4B P4B P1B 1e+12
Rleak_dc0 dc0 P1B 1e+12
Rleak_dc1 dc1 P1B 1e+12
Rleak_dc2 dc2 P1B 1e+12
Rleak_dc3 dc3 P1B 1e+12
Rleak_rlc0 rlc0 P1B 1e+12
Rleak_rlc1 rlc1 P1B 1e+12
Rleak_rlc10 rlc10 P1B 1e+12
Rleak_rlc11 rlc11 P1B 1e+12
Rleak_rlc12 rlc12 P1B 1e+12
Rleak_rlc13 rlc13 P1B 1e+12
Rleak_rlc14 rlc14 P1B 1e+12
Rleak_rlc15 rlc15 P1B 1e+12
Rleak_rlc2 rlc2 P1B 1e+12
Rleak_rlc3 rlc3 P1B 1e+12
Rleak_rlc4 rlc4 P1B 1e+12
Rleak_rlc5 rlc5 P1B 1e+12
Rleak_rlc6 rlc6 P1B 1e+12
Rleak_rlc7 rlc7 P1B 1e+12
Rleak_rlc8 rlc8 P1B 1e+12
Rleak_rlc9 rlc9 P1B 1e+12
.ends fitted
