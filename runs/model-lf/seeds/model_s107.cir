* fitted: 4-port fitted model, reference z0 = 50 Ohm
* port p is PpA (+) to PpB (-); the reference node is P1B
.subckt fitted P1A P1B P2A P2B P3A P3B P4A P4B
* ---- branches
* RLC[1] P1A-P3A
Rrlc1 P1A nrlc1_1 3600.69761395
Lrlc1 nrlc1_1 nrlc1_2 1.46218516501e-10
Crlc1 nrlc1_2 P3A 3.46210904032e-14
* RLC[4] P1A-P2B
Rrlc4 P1A nrlc4_1 5355.54541358
Lrlc4 nrlc4_1 nrlc4_2 0.00107137443536
Crlc4 nrlc4_2 P2B 4.15041340473e-14
* RLC[5] P1A-P3B
Rrlc5 P1A nrlc5_1 35827.3551045
Lrlc5 nrlc5_1 nrlc5_2 0.000246937896796
Crlc5 nrlc5_2 P3B 2.98759203531e-13
* RLC[7] P1A-rlc0
Rrlc7 P1A nrlc7_1 94.2775307106
Lrlc7 nrlc7_1 nrlc7_2 3.77262731247e-06
Crlc7 nrlc7_2 rlc0 4.71612162789e-13
* RLC[10] P1A-rlc3
Rrlc10 P1A nrlc10_1 15869.5661936
Lrlc10 nrlc10_1 nrlc10_2 0.00450481667231
Crlc10 nrlc10_2 rlc3 1.98748793933e-14
* RLC[13] P1A-rlc6
Rrlc13 P1A nrlc13_1 602516.651061
Lrlc13 nrlc13_1 nrlc13_2 2.00292006342e-07
Crlc13 nrlc13_2 rlc6 2.38362405219e-13
* RLC[16] P1A-rlc9
Rrlc16 P1A nrlc16_1 445.385152814
Lrlc16 nrlc16_1 nrlc16_2 8.27929782021e-07
Crlc16 nrlc16_2 rlc9 1.429857674e-12
* RLC[17] P1A-rlc10
Rrlc17 P1A nrlc17_1 4095.78746154
Lrlc17 nrlc17_1 nrlc17_2 0.000639640830395
Crlc17 nrlc17_2 rlc10 4.23661348923e-14
* RLC[21] P1A-rlc14
Rrlc21 P1A nrlc21_1 6787995.07537
Lrlc21 nrlc21_1 nrlc21_2 0.0436756482055
Crlc21 nrlc21_2 rlc14 1.78904395412e-13
* RLC[26] P2A-P1B
Rrlc26 P2A nrlc26_1 153381005793
Lrlc26 nrlc26_1 nrlc26_2 0.999069772595
Crlc26 nrlc26_2 P1B 7.41639984311e-08
* RLC[34] P2A-rlc4
Rrlc34 P2A nrlc34_1 2604.50929098
Lrlc34 nrlc34_1 nrlc34_2 0.000367757829555
Crlc34 nrlc34_2 rlc4 6.02375911045e-14
* RLC[35] P2A-rlc5
Rrlc35 P2A nrlc35_1 99.718688319
Lrlc35 nrlc35_1 nrlc35_2 3.84416111205e-06
Crlc35 nrlc35_2 rlc5 4.29542318647e-13
* RLC[36] P2A-rlc6
Rrlc36 P2A nrlc36_1 4.56172527038
Lrlc36 nrlc36_1 nrlc36_2 1.63374577597e-07
Crlc36 nrlc36_2 rlc6 8.72335839346e-12
* RLC[37] P2A-rlc7
Rrlc37 P2A nrlc37_1 26969.1773568
Lrlc37 nrlc37_1 nrlc37_2 0.00855818516186
Crlc37 nrlc37_2 rlc7 1.30738582036e-14
* RLC[41] P2A-rlc11
Rrlc41 P2A nrlc41_1 3641.26049492
Lrlc41 nrlc41_1 nrlc41_2 3.85342369907e-07
Crlc41 nrlc41_2 rlc11 6.9125386146e-14
* RLC[44] P2A-rlc14
Rrlc44 P2A nrlc44_1 214073929998
Lrlc44 nrlc44_1 nrlc44_2 0.885376423417
Crlc44 nrlc44_2 rlc14 1.93885535268e-08
* RLC[45] P2A-rlc15
Rrlc45 P2A nrlc45_1 438166.801237
Lrlc45 nrlc45_1 nrlc45_2 1.57696676951e-08
Crlc45 nrlc45_2 rlc15 1.16215090449e-13
* RLC[46] P2A-P1B
Rrlc46 P2A nrlc46_1 2487.093608
Lrlc46 nrlc46_1 nrlc46_2 0.000311984639927
Crlc46 nrlc46_2 P1B 5.6041072824e-14
* RLC[48] P3A-P1B
Rrlc48 P3A nrlc48_1 577.428881685
Lrlc48 nrlc48_1 nrlc48_2 9.37461941567e-07
Crlc48 nrlc48_2 P1B 8.63847138671e-13
* RLC[49] P3A-P2B
Rrlc49 P3A nrlc49_1 127351995550
Lrlc49 nrlc49_1 nrlc49_2 0.00314338023217
Crlc49 nrlc49_2 P2B 4.80916587669e-07
* RLC[53] P3A-rlc1
Rrlc53 P3A nrlc53_1 25.3217791785
Lrlc53 nrlc53_1 nrlc53_2 9.7351472406e-07
Crlc53 nrlc53_2 rlc1 1.68698639714e-12
* RLC[54] P3A-rlc2
Rrlc54 P3A nrlc54_1 5382.7526345
Lrlc54 nrlc54_1 nrlc54_2 0.001207936407
Crlc54 nrlc54_2 rlc2 4.63225775681e-14
* RLC[56] P3A-rlc4
Rrlc56 P3A nrlc56_1 696437.902309
Lrlc56 nrlc56_1 nrlc56_2 1.64704133162e-07
Crlc56 nrlc56_2 rlc4 3.50812071532e-13
* RLC[57] P3A-rlc5
Rrlc57 P3A nrlc57_1 19984705.0361
Lrlc57 nrlc57_1 nrlc57_2 1
Crlc57 nrlc57_2 rlc5 5.92830341064e-14
* RLC[58] P3A-rlc6
Rrlc58 P3A nrlc58_1 11527.0209826
Lrlc58 nrlc58_1 nrlc58_2 0.00404157621472
Crlc58 nrlc58_2 rlc6 3.37966843949e-14
* RLC[59] P3A-rlc7
Rrlc59 P3A nrlc59_1 7740.68705909
Lrlc59 nrlc59_1 nrlc59_2 0.00218628346957
Crlc59 nrlc59_2 rlc7 4.05419787247e-14
* RLC[60] P3A-rlc8
Rrlc60 P3A nrlc60_1 24241.9528117
Lrlc60 nrlc60_1 nrlc60_2 0.0108895411107
Crlc60 nrlc60_2 rlc8 2.05888394172e-14
* RLC[63] P3A-rlc11
Rrlc63 P3A nrlc63_1 5586.7128502
Lrlc63 nrlc63_1 nrlc63_2 0.00141145516814
Crlc63 nrlc63_2 rlc11 5.02472015481e-14
* RLC[64] P3A-rlc12
Rrlc64 P3A nrlc64_1 3596.63751607
Lrlc64 nrlc64_1 nrlc64_2 0.000642576528894
Crlc64 nrlc64_2 rlc12 5.51936364592e-14
* RLC[66] P3A-rlc14
Rrlc66 P3A nrlc66_1 6.92126496723
Lrlc66 nrlc66_1 nrlc66_2 2.68533119271e-07
Crlc66 nrlc66_2 rlc14 6.22851329527e-12
* RLC[67] P3A-rlc15
Rrlc67 P3A nrlc67_1 4017.20304329
Lrlc67 nrlc67_1 nrlc67_2 0.000803347587337
Crlc67 nrlc67_2 rlc15 5.53112429779e-14
* RLC[68] P3A-P1B
Rrlc68 P3A nrlc68_1 447.336609967
Lrlc68 nrlc68_1 nrlc68_2 1.66902178195e-06
Crlc68 nrlc68_2 P1B 6.12623892996e-13
* RLC[69] P4A-P1B
Rrlc69 P4A nrlc69_1 6753.09702149
Lrlc69 nrlc69_1 nrlc69_2 0.000203552662769
Crlc69 nrlc69_2 P1B 1.11076369334e-13
* RLC[70] P4A-P2B
Rrlc70 P4A nrlc70_1 60997.0492903
Lrlc70 nrlc70_1 nrlc70_2 0.000567948688095
Crlc70 nrlc70_2 P2B 5.08270324272e-13
* RLC[71] P4A-P3B
Rrlc71 P4A nrlc71_1 10075.955779
Lrlc71 nrlc71_1 nrlc71_2 0.00320243460942
Crlc71 nrlc71_2 P3B 3.50481626456e-14
* RLC[76] P4A-rlc3
Rrlc76 P4A nrlc76_1 339.90693931
Lrlc76 nrlc76_1 nrlc76_2 6.84358179203e-07
Crlc76 nrlc76_2 rlc3 1.66097194388e-12
* RLC[77] P4A-rlc4
Rrlc77 P4A nrlc77_1 7525815.5639
Lrlc77 nrlc77_1 nrlc77_2 2.65918502429e-06
Crlc77 nrlc77_2 rlc4 1.41549575782e-13
* RLC[81] P4A-rlc8
Rrlc81 P4A nrlc81_1 196.406204464
Lrlc81 nrlc81_1 nrlc81_2 8.26648250554e-06
Crlc81 nrlc81_2 rlc8 2.38104627296e-13
* RLC[82] P4A-rlc9
Rrlc82 P4A nrlc82_1 2035.83983276
Lrlc82 nrlc82_1 nrlc82_2 6.65656064983e-13
Crlc82 nrlc82_2 rlc9 1.35913556083e-13
* RLC[83] P4A-rlc10
Rrlc83 P4A nrlc83_1 7.3306799878
Lrlc83 nrlc83_1 nrlc83_2 2.8492068161e-07
Crlc83 nrlc83_2 rlc10 5.89105317103e-12
* RLC[84] P4A-rlc11
Rrlc84 P4A nrlc84_1 40593514.6113
Lrlc84 nrlc84_1 nrlc84_2 7.90845370868e-06
Crlc84 nrlc84_2 rlc11 4.99226512495e-14
* RLC[91] P1B-P3B
Rrlc91 P1B nrlc91_1 414.563437364
Lrlc91 nrlc91_1 nrlc91_2 5.55742378352e-06
Crlc91 nrlc91_2 P3B 2.03206929897e-10
* RLC[92] P1B-P4B
Rrlc92 P1B nrlc92_1 33724.4938762
Lrlc92 nrlc92_1 nrlc92_2 1
Crlc92 nrlc92_2 P4B 6.64210685116e-06
* RLC[93] P1B-rlc0
Rrlc93 P1B nrlc93_1 0.356539578385
Lrlc93 nrlc93_1 nrlc93_2 2.28514620231e-08
Crlc93 nrlc93_2 rlc0 1.99735834585e-10
* RLC[95] P1B-rlc2
Rrlc95 P1B nrlc95_1 42.4237855053
Lrlc95 nrlc95_1 nrlc95_2 8.16175557306e-06
Crlc95 nrlc95_2 rlc2 1.22108592244e-11
* RLC[99] P1B-rlc6
Rrlc99 P1B nrlc99_1 46.9801039694
Lrlc99 nrlc99_1 nrlc99_2 1.70142551115e-06
Crlc99 nrlc99_2 rlc6 3.25748657869e-10
* RLC[100] P1B-rlc7
Rrlc100 P1B nrlc100_1 8.47631212906
Lrlc100 nrlc100_1 nrlc100_2 1.13389884978e-06
Crlc100 nrlc100_2 rlc7 1.75354907257e-11
* RLC[101] P1B-rlc8
Rrlc101 P1B nrlc101_1 0.470167974793
Lrlc101 nrlc101_1 nrlc101_2 8.5609928854e-09
Crlc101 nrlc101_2 rlc8 3.65675221614e-09
* RLC[102] P1B-rlc9
Rrlc102 P1B nrlc102_1 2.54175257593
Lrlc102 nrlc102_1 nrlc102_2 2.68238758158e-06
Crlc102 nrlc102_2 rlc9 1.40433148624e-06
* RLC[105] P1B-rlc12
Rrlc105 P1B nrlc105_1 8.61542919151
Lrlc105 nrlc105_1 nrlc105_2 1.80342197789e-07
Crlc105 nrlc105_2 rlc12 5.69329667499e-08
* RLC[106] P1B-rlc13
Rrlc106 P1B nrlc106_1 0.542933724918
Lrlc106 nrlc106_1 nrlc106_2 1.3392714744e-08
Crlc106 nrlc106_2 rlc13 2.00050129331e-07
* RLC[110] P2B-P3B
Rrlc110 P2B nrlc110_1 34.7775070485
Lrlc110 nrlc110_1 nrlc110_2 3.16484477084e-05
Crlc110 nrlc110_2 P3B 1.73365647219e-08
* RLC[111] P2B-P4B
Rrlc111 P2B nrlc111_1 128.056213377
Lrlc111 nrlc111_1 nrlc111_2 0.00131403610728
Crlc111 nrlc111_2 P4B 4.98360977823e-06
* RLC[112] P2B-rlc0
Rrlc112 P2B nrlc112_1 0.96847442722
Lrlc112 nrlc112_1 nrlc112_2 2.7384402533e-06
Crlc112 nrlc112_2 rlc0 0.000177221506107
* RLC[113] P2B-rlc1
Rrlc113 P2B nrlc113_1 1400.50726368
Lrlc113 nrlc113_1 nrlc113_2 0.0305450088862
Crlc113 nrlc113_2 rlc1 0.000173860041112
* RLC[116] P2B-rlc4
Rrlc116 P2B nrlc116_1 141.717716054
Lrlc116 nrlc116_1 nrlc116_2 4.68663887689e-10
Crlc116 nrlc116_2 rlc4 3.51911208656e-09
* RLC[117] P2B-rlc5
Rrlc117 P2B nrlc117_1 103.917913707
Lrlc117 nrlc117_1 nrlc117_2 0.0679063977697
Crlc117 nrlc117_2 rlc5 0.000412581570828
* RLC[119] P2B-rlc7
Rrlc119 P2B nrlc119_1 0.864926972832
Lrlc119 nrlc119_1 nrlc119_2 6.99768755202e-06
Crlc119 nrlc119_2 rlc7 0.000209817592958
* RLC[120] P2B-rlc8
Rrlc120 P2B nrlc120_1 0.01
Lrlc120 nrlc120_1 nrlc120_2 2.16602465743e-07
Crlc120 nrlc120_2 rlc8 5.73305557823e-05
* RLC[122] P2B-rlc10
Rrlc122 P2B nrlc122_1 18.2759701931
Lrlc122 nrlc122_1 nrlc122_2 2.90241856684e-06
Crlc122 nrlc122_2 rlc10 1.44394045851e-08
* RLC[126] P2B-rlc14
Rrlc126 P2B nrlc126_1 0.624046166245
Lrlc126 nrlc126_1 nrlc126_2 1.10370303427e-06
Crlc126 nrlc126_2 rlc14 6.38013107647e-05
* RLC[127] P2B-rlc15
Rrlc127 P2B nrlc127_1 86.1040617183
Lrlc127 nrlc127_1 nrlc127_2 0.033858520868
Crlc127 nrlc127_2 rlc15 0.00017849823757
* RLC[128] P2B-P1B
Rrlc128 P2B nrlc128_1 56.1224281959
Lrlc128 nrlc128_1 nrlc128_2 1.27032176971e-06
Crlc128 nrlc128_2 P1B 9.29622627883e-10
* RLC[132] P3B-rlc2
Rrlc132 P3B nrlc132_1 101.89372088
Lrlc132 nrlc132_1 nrlc132_2 0.020457321832
Crlc132 nrlc132_2 rlc2 0.000212363185911
* RLC[133] P3B-rlc3
Rrlc133 P3B nrlc133_1 75.0142221605
Lrlc133 nrlc133_1 nrlc133_2 3.33067104988e-06
Crlc133 nrlc133_2 rlc3 1.56062440114e-11
* RLC[134] P3B-rlc4
Rrlc134 P3B nrlc134_1 6.28294700368
Lrlc134 nrlc134_1 nrlc134_2 9.96979471289e-07
Crlc134 nrlc134_2 rlc4 6.47002019409e-09
* RLC[135] P3B-rlc5
Rrlc135 P3B nrlc135_1 0.01
Lrlc135 nrlc135_1 nrlc135_2 3.97134440978e-08
Crlc135 nrlc135_2 rlc5 7.63931558532e-06
* RLC[137] P3B-rlc7
Rrlc137 P3B nrlc137_1 93.2346155222
Lrlc137 nrlc137_1 nrlc137_2 0.0717530505008
Crlc137 nrlc137_2 rlc7 0.00023355472172
* RLC[138] P3B-rlc8
Rrlc138 P3B nrlc138_1 142.75280018
Lrlc138 nrlc138_1 nrlc138_2 1.1804435378e-05
Crlc138 nrlc138_2 rlc8 9.63529620716e-12
* RLC[140] P3B-rlc10
Rrlc140 P3B nrlc140_1 47.9930607131
Lrlc140 nrlc140_1 nrlc140_2 9.41643831965e-06
Crlc140 nrlc140_2 rlc10 4.5424197292e-12
* RLC[141] P3B-rlc11
Rrlc141 P3B nrlc141_1 1.28828883907
Lrlc141 nrlc141_1 nrlc141_2 3.95499026438e-08
Crlc141 nrlc141_2 rlc11 6.30025125673e-07
* RLC[145] P3B-rlc15
Rrlc145 P3B nrlc145_1 50.282351792
Lrlc145 nrlc145_1 nrlc145_2 1.14998111887e-05
Crlc145 nrlc145_2 rlc15 9.17338864966e-12
* RLC[148] P4B-rlc1
Rrlc148 P4B nrlc148_1 28.7315936679
Lrlc148 nrlc148_1 nrlc148_2 4.42411543951e-06
Crlc148 nrlc148_2 rlc1 7.15602118483e-12
* RLC[149] P4B-rlc2
Rrlc149 P4B nrlc149_1 6.72706015124
Lrlc149 nrlc149_1 nrlc149_2 7.08841292222e-08
Crlc149 nrlc149_2 rlc2 2.2513678297e-08
* RLC[152] P4B-rlc5
Rrlc152 P4B nrlc152_1 5958.09966938
Lrlc152 nrlc152_1 nrlc152_2 1
Crlc152 nrlc152_2 rlc5 3.8440718631e-05
* RLC[153] P4B-rlc6
Rrlc153 P4B nrlc153_1 3725.95704334
Lrlc153 nrlc153_1 nrlc153_2 0.00627061031055
Crlc153 nrlc153_2 rlc6 6.77810502213e-09
* RLC[154] P4B-rlc7
Rrlc154 P4B nrlc154_1 27.1096808693
Lrlc154 nrlc154_1 nrlc154_2 1.13565056316e-05
Crlc154 nrlc154_2 rlc7 1.7169332089e-11
* RLC[156] P4B-rlc9
Rrlc156 P4B nrlc156_1 1.93374637001
Lrlc156 nrlc156_1 nrlc156_2 3.45063385999e-07
Crlc156 nrlc156_2 rlc9 5.07736264481e-07
* RLC[157] P4B-rlc10
Rrlc157 P4B nrlc157_1 3.13282611767
Lrlc157 nrlc157_1 nrlc157_2 1.44880679686e-05
Crlc157 nrlc157_2 rlc10 7.75868168642e-06
* RLC[158] P4B-rlc11
Rrlc158 P4B nrlc158_1 0.0108740755509
Lrlc158 nrlc158_1 nrlc158_2 1.38569108223e-08
Crlc158 nrlc158_2 rlc11 1.25867777287e-05
* RLC[159] P4B-rlc12
Rrlc159 P4B nrlc159_1 24.1193585745
Lrlc159 nrlc159_1 nrlc159_2 1.22232444031e-05
Crlc159 nrlc159_2 rlc12 2.33459998257e-11
* RLC[160] P4B-rlc13
Rrlc160 P4B nrlc160_1 5.00176942942
Lrlc160 nrlc160_1 nrlc160_2 3.72924534169e-08
Crlc160 nrlc160_2 rlc13 1.50464180811e-09
* RLC[161] P4B-rlc14
Rrlc161 P4B nrlc161_1 3288.73756443
Lrlc161 nrlc161_1 nrlc161_2 0.0362118359476
Crlc161 nrlc161_2 rlc14 5.15029377188e-07
* RLC[162] P4B-rlc15
Rrlc162 P4B nrlc162_1 0.389180920135
Lrlc162 nrlc162_1 nrlc162_2 5.84410179651e-09
Crlc162 nrlc162_2 rlc15 9.99307004641e-06
* RLC[163] P4B-P1B
Rrlc163 P4B nrlc163_1 47.4941980031
Lrlc163 nrlc163_1 nrlc163_2 1.32078546192e-05
Crlc163 nrlc163_2 P1B 6.50591902403e-12
* RLC[164] rlc0-rlc1
Rrlc164 rlc0 nrlc164_1 5.78757044039
Lrlc164 nrlc164_1 nrlc164_2 3.67172165591e-07
Crlc164 nrlc164_2 rlc1 1.44533909633e-10
* RLC[165] rlc0-rlc2
Rrlc165 rlc0 nrlc165_1 1560.92499082
Lrlc165 nrlc165_1 nrlc165_2 0.0100890409866
Crlc165 nrlc165_2 rlc2 0.000653151765354
* RLC[166] rlc0-rlc3
Rrlc166 rlc0 nrlc166_1 6.25149979903
Lrlc166 nrlc166_1 nrlc166_2 1.08723348422e-06
Crlc166 nrlc166_2 rlc3 3.09109154086e-11
* RLC[169] rlc0-rlc6
Rrlc169 rlc0 nrlc169_1 15.1040070662
Lrlc169 nrlc169_1 nrlc169_2 9.92742054781e-07
Crlc169 nrlc169_2 rlc6 2.30138372532e-10
* RLC[170] rlc0-rlc7
Rrlc170 rlc0 nrlc170_1 0.068895637314
Lrlc170 nrlc170_1 nrlc170_2 1.91845277223e-09
Crlc170 nrlc170_2 rlc7 5.02366580686e-07
* RLC[171] rlc0-rlc8
Rrlc171 rlc0 nrlc171_1 23.0070161851
Lrlc171 nrlc171_1 nrlc171_2 0.0286799005495
Crlc171 nrlc171_2 rlc8 0.000130045003745
* RLC[172] rlc0-rlc9
Rrlc172 rlc0 nrlc172_1 11.8756387871
Lrlc172 nrlc172_1 nrlc172_2 5.5153803607e-07
Crlc172 nrlc172_2 rlc9 4.35552246022e-10
* RLC[173] rlc0-rlc10
Rrlc173 rlc0 nrlc173_1 0.0834450181832
Lrlc173 nrlc173_1 nrlc173_2 9.09650611487e-08
Crlc173 nrlc173_2 rlc10 7.54970076372e-05
* RLC[174] rlc0-rlc11
Rrlc174 rlc0 nrlc174_1 57.5896794504
Lrlc174 nrlc174_1 nrlc174_2 3.1389054835e-06
Crlc174 nrlc174_2 rlc11 4.06611926423e-12
* RLC[175] rlc0-rlc12
Rrlc175 rlc0 nrlc175_1 7.77735571196
Lrlc175 nrlc175_1 nrlc175_2 4.97864811914e-07
Crlc175 nrlc175_2 rlc12 4.03442470451e-10
* RLC[176] rlc0-rlc13
Rrlc176 rlc0 nrlc176_1 11.2038233463
Lrlc176 nrlc176_1 nrlc176_2 7.37810707387e-08
Crlc176 nrlc176_2 rlc13 3.60729109409e-09
* RLC[177] rlc0-rlc14
Rrlc177 rlc0 nrlc177_1 17.6860501697
Lrlc177 nrlc177_1 nrlc177_2 2.02986449414e-07
Crlc177 nrlc177_2 rlc14 8.48824514901e-11
* RLC[181] rlc1-rlc3
Rrlc181 rlc1 nrlc181_1 22.1766865026
Lrlc181 nrlc181_1 nrlc181_2 0.00279041735128
Crlc181 nrlc181_2 rlc3 1.49218315737e-06
* RLC[183] rlc1-rlc5
Rrlc183 rlc1 nrlc183_1 3.99800636753
Lrlc183 nrlc183_1 nrlc183_2 6.43708885577e-08
Crlc183 nrlc183_2 rlc5 3.02515021945e-09
* RLC[184] rlc1-rlc6
Rrlc184 rlc1 nrlc184_1 105.630773573
Lrlc184 nrlc184_1 nrlc184_2 1.22088363997e-05
Crlc184 nrlc184_2 rlc6 3.58253206658e-12
* RLC[185] rlc1-rlc7
Rrlc185 rlc1 nrlc185_1 4.87347694919
Lrlc185 nrlc185_1 nrlc185_2 2.26528968637e-07
Crlc185 nrlc185_2 rlc7 1.02127807334e-10
* RLC[186] rlc1-rlc8
Rrlc186 rlc1 nrlc186_1 15.0072077481
Lrlc186 nrlc186_1 nrlc186_2 2.27737766971e-06
Crlc186 nrlc186_2 rlc8 1.28024650336e-11
* RLC[188] rlc1-rlc10
Rrlc188 rlc1 nrlc188_1 17.4032319642
Lrlc188 nrlc188_1 nrlc188_2 1.68998805262e-06
Crlc188 nrlc188_2 rlc10 6.19985178435e-12
* RLC[189] rlc1-rlc11
Rrlc189 rlc1 nrlc189_1 2.01224949854
Lrlc189 nrlc189_1 nrlc189_2 2.76969613961e-07
Crlc189 nrlc189_2 rlc11 3.96353882079e-10
* RLC[190] rlc1-rlc12
Rrlc190 rlc1 nrlc190_1 1.58884559008
Lrlc190 nrlc190_1 nrlc190_2 1.77087783983e-07
Crlc190 nrlc190_2 rlc12 7.79440033317e-11
* RLC[191] rlc1-rlc13
Rrlc191 rlc1 nrlc191_1 17.9528359848
Lrlc191 nrlc191_1 nrlc191_2 3.21454680258e-06
Crlc191 nrlc191_2 rlc13 1.10818206553e-11
* RLC[192] rlc1-rlc14
Rrlc192 rlc1 nrlc192_1 8.01548767356
Lrlc192 nrlc192_1 nrlc192_2 1.51206300316e-07
Crlc192 nrlc192_2 rlc14 7.02894061342e-11
* RLC[193] rlc1-rlc15
Rrlc193 rlc1 nrlc193_1 23.9506972192
Lrlc193 nrlc193_1 nrlc193_2 3.28630564175e-06
Crlc193 nrlc193_2 rlc15 6.36545015807e-12
* RLC[197] rlc2-rlc5
Rrlc197 rlc2 nrlc197_1 12.401832368
Lrlc197 nrlc197_1 nrlc197_2 1.51347400238e-06
Crlc197 nrlc197_2 rlc5 8.32663955255e-09
* RLC[199] rlc2-rlc7
Rrlc199 rlc2 nrlc199_1 1.15182017235
Lrlc199 nrlc199_1 nrlc199_2 2.4084909082e-08
Crlc199 nrlc199_2 rlc7 1.65821598098e-08
* RLC[200] rlc2-rlc8
Rrlc200 rlc2 nrlc200_1 0.923708378112
Lrlc200 nrlc200_1 nrlc200_2 8.40019418657e-08
Crlc200 nrlc200_2 rlc8 1.0938985605e-10
* RLC[203] rlc2-rlc11
Rrlc203 rlc2 nrlc203_1 3.88988037639
Lrlc203 nrlc203_1 nrlc203_2 7.35487411133e-07
Crlc203 nrlc203_2 rlc11 6.42965589e-11
* RLC[205] rlc2-rlc13
Rrlc205 rlc2 nrlc205_1 4.53226412284
Lrlc205 nrlc205_1 nrlc205_2 1.01195226921e-06
Crlc205 nrlc205_2 rlc13 7.48626099599e-11
* RLC[207] rlc2-rlc15
Rrlc207 rlc2 nrlc207_1 6.43084805297
Lrlc207 nrlc207_1 nrlc207_2 7.43577220499e-07
Crlc207 nrlc207_2 rlc15 1.99777728446e-11
* RLC[209] rlc3-rlc4
Rrlc209 rlc3 nrlc209_1 476.858735915
Lrlc209 nrlc209_1 nrlc209_2 1.03777553998e-05
Crlc209 nrlc209_2 rlc4 9.90096816066e-12
* RLC[211] rlc3-rlc6
Rrlc211 rlc3 nrlc211_1 5.95574974516
Lrlc211 nrlc211_1 nrlc211_2 1.48864957776e-06
Crlc211 nrlc211_2 rlc6 1.11584916097e-10
* RLC[215] rlc3-rlc10
Rrlc215 rlc3 nrlc215_1 2.38774147624
Lrlc215 nrlc215_1 nrlc215_2 6.69151487824e-07
Crlc215 nrlc215_2 rlc10 1.30408930043e-10
* RLC[217] rlc3-rlc12
Rrlc217 rlc3 nrlc217_1 0.839803821911
Lrlc217 nrlc217_1 nrlc217_2 8.26177279823e-09
Crlc217 nrlc217_2 rlc12 1.41035299269e-09
* RLC[220] rlc3-rlc15
Rrlc220 rlc3 nrlc220_1 12.962049045
Lrlc220 nrlc220_1 nrlc220_2 3.22212729833e-06
Crlc220 nrlc220_2 rlc15 2.13084992769e-11
* RLC[221] rlc3-P1B
Rrlc221 rlc3 nrlc221_1 15.2817932039
Lrlc221 nrlc221_1 nrlc221_2 4.49341138758e-06
Crlc221 nrlc221_2 P1B 2.69714744e-11
* RLC[224] rlc4-rlc7
Rrlc224 rlc4 nrlc224_1 0.0874725228345
Lrlc224 nrlc224_1 nrlc224_2 0.00396082774053
Crlc224 nrlc224_2 rlc7 0.000575175184929
* RLC[226] rlc4-rlc9
Rrlc226 rlc4 nrlc226_1 315.538823003
Lrlc226 nrlc226_1 nrlc226_2 7.49452712498e-06
Crlc226 nrlc226_2 rlc9 3.55799015338e-11
* RLC[228] rlc4-rlc11
Rrlc228 rlc4 nrlc228_1 519.668110137
Lrlc228 nrlc228_1 nrlc228_2 1.10557754494e-06
Crlc228 nrlc228_2 rlc11 1.63638432017e-10
* RLC[231] rlc4-rlc14
Rrlc231 rlc4 nrlc231_1 6.42886573875
Lrlc231 nrlc231_1 nrlc231_2 1.76812787289e-07
Crlc231 nrlc231_2 rlc14 4.75337906406e-12
* RLC[232] rlc4-rlc15
Rrlc232 rlc4 nrlc232_1 2270.66406904
Lrlc232 nrlc232_1 nrlc232_2 0.241773678555
Crlc232 nrlc232_2 rlc15 0.000429187536035
* RLC[233] rlc4-P1B
Rrlc233 rlc4 nrlc233_1 40.521311872
Lrlc233 nrlc233_1 nrlc233_2 1.70233615567e-05
Crlc233 nrlc233_2 P1B 2.0869521888e-05
* RLC[234] rlc5-rlc6
Rrlc234 rlc5 nrlc234_1 41.232429596
Lrlc234 nrlc234_1 nrlc234_2 1.81568649919e-06
Crlc234 nrlc234_2 rlc6 1.38044316659e-11
* RLC[237] rlc5-rlc9
Rrlc237 rlc5 nrlc237_1 0.01
Lrlc237 nrlc237_1 nrlc237_2 1.06737987496e-07
Crlc237 nrlc237_2 rlc9 0.000280084396263
* RLC[238] rlc5-rlc10
Rrlc238 rlc5 nrlc238_1 25.8579962949
Lrlc238 nrlc238_1 nrlc238_2 2.48184105628e-06
Crlc238 nrlc238_2 rlc10 8.44807997451e-12
* RLC[239] rlc5-rlc11
Rrlc239 rlc5 nrlc239_1 15.2740333655
Lrlc239 nrlc239_1 nrlc239_2 7.57713440068e-07
Crlc239 nrlc239_2 rlc11 2.52044732297e-10
* RLC[240] rlc5-rlc12
Rrlc240 rlc5 nrlc240_1 46.9520791312
Lrlc240 nrlc240_1 nrlc240_2 2.68025181618e-06
Crlc240 nrlc240_2 rlc12 1.35435224442e-11
* RLC[241] rlc5-rlc13
Rrlc241 rlc5 nrlc241_1 260.366217105
Lrlc241 nrlc241_1 nrlc241_2 2.49191743045e-05
Crlc241 nrlc241_2 rlc13 2.01339888279e-12
* RLC[242] rlc5-rlc14
Rrlc242 rlc5 nrlc242_1 0.653140547208
Lrlc242 nrlc242_1 nrlc242_2 6.61182674259e-12
Crlc242 nrlc242_2 rlc14 2.17578101777e-06
* RLC[245] rlc6-rlc7
Rrlc245 rlc6 nrlc245_1 152.792907476
Lrlc245 nrlc245_1 nrlc245_2 1.69602062317e-05
Crlc245 nrlc245_2 rlc7 5.51089958616e-07
* RLC[248] rlc6-rlc10
Rrlc248 rlc6 nrlc248_1 0.01
Lrlc248 nrlc248_1 nrlc248_2 3.71115728471e-11
Crlc248 nrlc248_2 rlc10 1.88821999681e-09
* RLC[249] rlc6-rlc11
Rrlc249 rlc6 nrlc249_1 79.3878162997
Lrlc249 nrlc249_1 nrlc249_2 3.55565054412e-06
Crlc249 nrlc249_2 rlc11 3.6953528287e-12
* RLC[253] rlc6-rlc15
Rrlc253 rlc6 nrlc253_1 10.5100982716
Lrlc253 nrlc253_1 nrlc253_2 2.14121906402e-06
Crlc253 nrlc253_2 rlc15 9.19310579934e-11
* RLC[255] rlc7-rlc8
Rrlc255 rlc7 nrlc255_1 0.107421058782
Lrlc255 nrlc255_1 nrlc255_2 2.29149409544e-06
Crlc255 nrlc255_2 rlc8 1.00952542533e-05
* RLC[256] rlc7-rlc9
Rrlc256 rlc7 nrlc256_1 5.86884488996
Lrlc256 nrlc256_1 nrlc256_2 4.58660968168e-06
Crlc256 nrlc256_2 rlc9 2.5190083396e-07
* RLC[258] rlc7-rlc11
Rrlc258 rlc7 nrlc258_1 0.0218839855875
Lrlc258 nrlc258_1 nrlc258_2 1.72052826506e-10
Crlc258 nrlc258_2 rlc11 3.99177875143e-10
* RLC[259] rlc7-rlc12
Rrlc259 rlc7 nrlc259_1 9.87332236658
Lrlc259 nrlc259_1 nrlc259_2 8.07593558524e-07
Crlc259 nrlc259_2 rlc12 1.60742081221e-08
* RLC[260] rlc7-rlc13
Rrlc260 rlc7 nrlc260_1 3.94323108043
Lrlc260 nrlc260_1 nrlc260_2 7.12977131749e-08
Crlc260 nrlc260_2 rlc13 3.78632916161e-10
* RLC[261] rlc7-rlc14
Rrlc261 rlc7 nrlc261_1 1.0565291334
Lrlc261 nrlc261_1 nrlc261_2 1.02470830844e-06
Crlc261 nrlc261_2 rlc14 3.56041873993e-06
* RLC[269] rlc8-rlc14
Rrlc269 rlc8 nrlc269_1 32.2424243911
Lrlc269 nrlc269_1 nrlc269_2 1.63247228333e-05
Crlc269 nrlc269_2 rlc14 6.97946848037e-05
* RLC[271] rlc8-P1B
Rrlc271 rlc8 nrlc271_1 1.32391384531
Lrlc271 nrlc271_1 nrlc271_2 1.1691226433e-08
Crlc271 nrlc271_2 P1B 6.28353201062e-07
* RLC[272] rlc9-rlc10
Rrlc272 rlc9 nrlc272_1 8.7847572113
Lrlc272 nrlc272_1 nrlc272_2 7.95863543649e-07
Crlc272 nrlc272_2 rlc10 1.35740313782e-10
* RLC[273] rlc9-rlc11
Rrlc273 rlc9 nrlc273_1 10216.0422668
Lrlc273 nrlc273_1 nrlc273_2 0.493974153817
Crlc273 nrlc273_2 rlc11 1.12648697837e-06
* RLC[277] rlc9-rlc15
Rrlc277 rlc9 nrlc277_1 2.36738147275
Lrlc277 nrlc277_1 nrlc277_2 1.48623342655e-08
Crlc277 nrlc277_2 rlc15 6.31661292903e-08
* RLC[278] rlc9-P1B
Rrlc278 rlc9 nrlc278_1 3.71954355584
Lrlc278 nrlc278_1 nrlc278_2 3.08294805141e-07
Crlc278 nrlc278_2 P1B 2.47596442299e-11
* RLC[280] rlc10-rlc12
Rrlc280 rlc10 nrlc280_1 0.722788962589
Lrlc280 nrlc280_1 nrlc280_2 7.31792168423e-08
Crlc280 nrlc280_2 rlc12 1.08726097082e-09
* RLC[282] rlc10-rlc14
Rrlc282 rlc10 nrlc282_1 2.89779047313
Lrlc282 nrlc282_1 nrlc282_2 5.16126097402e-06
Crlc282 nrlc282_2 rlc14 3.91121498303e-05
* RLC[283] rlc10-rlc15
Rrlc283 rlc10 nrlc283_1 7.67054038945
Lrlc283 nrlc283_1 nrlc283_2 0.000116129053718
Crlc283 nrlc283_2 rlc15 1.69067398428e-05
* RLC[284] rlc10-P1B
Rrlc284 rlc10 nrlc284_1 18.4833689492
Lrlc284 nrlc284_1 nrlc284_2 5.48351987421e-07
Crlc284 nrlc284_2 P1B 1.26140268215e-10
* RLC[285] rlc11-rlc12
Rrlc285 rlc11 nrlc285_1 32.9329874076
Lrlc285 nrlc285_1 nrlc285_2 2.28554310567e-06
Crlc285 nrlc285_2 rlc12 2.29910544931e-11
* RLC[286] rlc11-rlc13
Rrlc286 rlc11 nrlc286_1 22.5862532909
Lrlc286 nrlc286_1 nrlc286_2 1.71923804678e-13
Crlc286 nrlc286_2 rlc13 1.90282223052e-09
* RLC[287] rlc11-rlc14
Rrlc287 rlc11 nrlc287_1 0.0108732169272
Lrlc287 nrlc287_1 nrlc287_2 3.62965598324e-08
Crlc287 nrlc287_2 rlc14 6.8140907137e-06
* RLC[292] rlc12-rlc15
Rrlc292 rlc12 nrlc292_1 0.54408372503
Lrlc292 nrlc292_1 nrlc292_2 7.97317752413e-08
Crlc292 nrlc292_2 rlc15 3.2635685926e-06
* RLC[293] rlc12-P1B
Rrlc293 rlc12 nrlc293_1 36.3984348097
Lrlc293 nrlc293_1 nrlc293_2 5.36363260623e-07
Crlc293 nrlc293_2 P1B 7.5295890011e-10
* RLC[294] rlc13-rlc14
Rrlc294 rlc13 nrlc294_1 21.4355548368
Lrlc294 nrlc294_1 nrlc294_2 5.85815343706e-06
Crlc294 nrlc294_2 rlc14 1.41660501398e-11
* RLC[296] rlc13-P1B
Rrlc296 rlc13 nrlc296_1 0.0153578751928
Lrlc296 nrlc296_1 nrlc296_2 1.9313876234e-09
Crlc296 nrlc296_2 P1B 9.63117948364e-08
* RLC[297] rlc14-rlc15
Rrlc297 rlc14 nrlc297_1 8.04850950569
Lrlc297 nrlc297_1 nrlc297_2 1.45166969703e-07
Crlc297 nrlc297_2 rlc15 2.76185649071e-09
* RLC[299] rlc15-P1B
Rrlc299 rlc15 nrlc299_1 8.50852816081
Lrlc299 nrlc299_1 nrlc299_2 3.50089333843e-07
Crlc299 nrlc299_2 P1B 8.2033565431e-11
* DC[0] P1A-P2A
Rdc0 P1A ndc0_1 0.0153954277305
Ldc0 ndc0_1 P2A 5.60909654875e-08
* DC[23] P3A-P4A
Rdc23 P3A ndc23_1 0.0125623571511
Ldc23 ndc23_1 P4A 1.22349668463e-07
* DC[42] P1B-P2B
Rdc42 P1B ndc42_1 8.49114753096
Ldc42 ndc42_1 P2B 2.69478692827e-06
* DC[43] P1B-P3B
Rdc43 P1B ndc43_1 853.13958403
Ldc43 ndc43_1 P3B 0.000135781381946
* DC[46] P1B-dc1
Rdc46 P1B ndc46_1 27.8652738853
Ldc46 ndc46_1 dc1 4.63265432985e-05
* DC[47] P1B-dc2
Rdc47 P1B ndc47_1 82.4558847178
Ldc47 ndc47_1 dc2 1.4167679084e-05
* DC[51] P2B-P4B
Rdc51 P2B ndc51_1 30249.7299957
Ldc51 ndc51_1 P4B 0.0480766143091
* DC[52] P2B-dc0
Rdc52 P2B ndc52_1 0.320252220557
Ldc52 ndc52_1 dc0 4.76324562311e-06
* DC[54] P2B-dc2
Rdc54 P2B ndc54_1 8.96719777444
Ldc54 ndc54_1 dc2 0.00862574233711
* DC[55] P2B-dc3
Rdc55 P2B ndc55_1 0.0464766679268
Ldc55 ndc55_1 dc3 6.4561413676e-07
* DC[56] P2B-P1B
Rdc56 P2B ndc56_1 0.106939596271
Ldc56 ndc56_1 P1B 7.34543482978e-08
* DC[57] P3B-P4B
Rdc57 P3B ndc57_1 0.122637745738
Ldc57 ndc57_1 P4B 8.99473720095e-08
* DC[59] P3B-dc1
Rdc59 P3B ndc59_1 20.000185089
Ldc59 ndc59_1 dc1 0.00015371199386
* DC[60] P3B-dc2
Rdc60 P3B ndc60_1 0.0100053211622
Ldc60 ndc60_1 dc2 3.32725339816e-06
* DC[61] P3B-dc3
Rdc61 P3B ndc61_1 4.63521094514
Ldc61 ndc61_1 dc3 2.59282409052e-05
* DC[62] P3B-P1B
Rdc62 P3B ndc62_1 928.389721341
Ldc62 ndc62_1 P1B 0.000147757813267
* DC[63] P4B-dc0
Rdc63 P4B ndc63_1 2.70110696012
Ldc63 ndc63_1 dc0 0.000103740475057
* DC[67] P4B-P1B
Rdc67 P4B ndc67_1 80004.8598857
Ldc67 ndc67_1 P1B 0.911215883443
* DC[68] dc0-dc1
Rdc68 dc0 ndc68_1 0.01
Ldc68 ndc68_1 dc1 0.000425021372002
* DC[69] dc0-dc2
Rdc69 dc0 ndc69_1 0.0100321359852
Ldc69 ndc69_1 dc2 2.97774506476e-05
* DC[71] dc0-P1B
Rdc71 dc0 ndc71_1 4.06811552267
Ldc71 ndc71_1 P1B 7.94290721758e-05
* DC[72] dc1-dc2
Rdc72 dc1 ndc72_1 0.381176196191
Ldc72 ndc72_1 dc2 6.55194129341e-08
* DC[74] dc1-P1B
Rdc74 dc1 ndc74_1 2.0399084455
Ldc74 ndc74_1 P1B 3.35452700444e-06
* DC[75] dc2-dc3
Rdc75 dc2 ndc75_1 7.0321606773
Ldc75 ndc75_1 dc3 1.19972919197e-06
* DC[76] dc2-P1B
Rdc76 dc2 ndc76_1 886.404833435
Ldc76 ndc76_1 P1B 0.000152294537083
* DC[77] dc3-P1B
Rdc77 dc3 ndc77_1 0.198073241153
Ldc77 ndc77_1 P1B 3.15622307193e-08
* ---- leaks
Rleak_P1A P1A P1B 1e+12
Rleak_P2A P2A P1B 1e+12
Rleak_P2B P2B P1B 1e+12
Rleak_P3A P3A P1B 1e+12
Rleak_P3B P3B P1B 1e+12
Rleak_P4A P4A P1B 1e+12
Rleak_P4B P4B P1B 1e+12
Rleak_dc0 dc0 P1B 1e+12
Rleak_dc1 dc1 P1B 1e+12
Rleak_dc2 dc2 P1B 1e+12
Rleak_dc3 dc3 P1B 1e+12
Rleak_rlc0 rlc0 P1B 1e+12
Rleak_rlc1 rlc1 P1B 1e+12
Rleak_rlc10 rlc10 P1B 1e+12
Rleak_rlc11 rlc11 P1B 1e+12
Rleak_rlc12 rlc12 P1B 1e+12
Rleak_rlc13 rlc13 P1B 1e+12
Rleak_rlc14 rlc14 P1B 1e+12
Rleak_rlc15 rlc15 P1B 1e+12
Rleak_rlc2 rlc2 P1B 1e+12
Rleak_rlc3 rlc3 P1B 1e+12
Rleak_rlc4 rlc4 P1B 1e+12
Rleak_rlc5 rlc5 P1B 1e+12
Rleak_rlc6 rlc6 P1B 1e+12
Rleak_rlc7 rlc7 P1B 1e+12
Rleak_rlc8 rlc8 P1B 1e+12
Rleak_rlc9 rlc9 P1B 1e+12
.ends fitted
