* fitted: 4-port fitted model, reference z0 = 50 Ohm
* port p is PpA (+) to PpB (-); the reference node is P1B
.subckt fitted P1A P1B P2A P2B P3A P3B P4A P4B
* ---- branches
* RLC[1] P1A-P3A
Rrlc1 P1A nrlc1_1 1.38779071632e+13
Lrlc1 nrlc1_1 nrlc1_2 5.49533180015e-07
Crlc1 nrlc1_2 P3A 9.13474228756e-12
* RLC[2] P1A-P4A
Rrlc2 P1A nrlc2_1 3.33528466515e+13
Lrlc2 nrlc2_1 nrlc2_2 0.159945986696
Crlc2 nrlc2_2 P4A 9.58841434028e-11
* RLC[3] P1A-P1B
Rrlc3 P1A nrlc3_1 1463634.84366
Lrlc3 nrlc3_1 nrlc3_2 0.0850275904266
Crlc3 nrlc3_2 P1B 1.52045317211e-13
* RLC[5] P1A-P3B
Rrlc5 P1A nrlc5_1 139790760712
Lrlc5 nrlc5_1 nrlc5_2 2.11183060994e-08
Crlc5 nrlc5_2 P3B 7.04081494057e-11
* RLC[8] P1A-rlc1
Rrlc8 P1A nrlc8_1 18.8855478317
Lrlc8 nrlc8_1 nrlc8_2 5.35025143414e-07
Crlc8 nrlc8_2 rlc1 1.66675784513e-12
* RLC[9] P1A-rlc2
Rrlc9 P1A nrlc9_1 8518986.29508
Lrlc9 nrlc9_1 nrlc9_2 1.52394343989e-05
Crlc9 nrlc9_2 rlc2 1.55065171634e-13
* RLC[11] P1A-rlc4
Rrlc11 P1A nrlc11_1 14411.7666423
Lrlc11 nrlc11_1 nrlc11_2 0.000158409391346
Crlc11 nrlc11_2 rlc4 1.66516186018e-13
* RLC[13] P1A-rlc6
Rrlc13 P1A nrlc13_1 85425.3580022
Lrlc13 nrlc13_1 nrlc13_2 0.042711732874
Crlc13 nrlc13_2 rlc6 6.50325924826e-15
* RLC[15] P1A-rlc8
Rrlc15 P1A nrlc15_1 263561011250
Lrlc15 nrlc15_1 nrlc15_2 3.22629967748e-08
Crlc15 nrlc15_2 rlc8 2.34425510696e-11
* RLC[16] P1A-rlc9
Rrlc16 P1A nrlc16_1 3.978770578
Lrlc16 nrlc16_1 nrlc16_2 1.16298727566e-07
Crlc16 nrlc16_2 rlc9 8.16274350972e-12
* RLC[17] P1A-rlc10
Rrlc17 P1A nrlc17_1 33.8928439817
Lrlc17 nrlc17_1 nrlc17_2 1.17234404494e-06
Crlc17 nrlc17_2 rlc10 1.13398574987e-12
* RLC[18] P1A-rlc11
Rrlc18 P1A nrlc18_1 1175.65556464
Lrlc18 nrlc18_1 nrlc18_2 9.13324856281e-13
Crlc18 nrlc18_2 rlc11 2.77510881526e-13
* RLC[19] P1A-rlc12
Rrlc19 P1A nrlc19_1 497.432578246
Lrlc19 nrlc19_1 nrlc19_2 1.12081380295e-05
Crlc19 nrlc19_2 rlc12 9.10234302165e-14
* RLC[27] P2A-P2B
Rrlc27 P2A nrlc27_1 494018.502681
Lrlc27 nrlc27_1 nrlc27_2 1
Crlc27 nrlc27_2 P2B 7.8508519803e-15
* RLC[35] P2A-rlc5
Rrlc35 P2A nrlc35_1 8045.50646874
Lrlc35 nrlc35_1 nrlc35_2 0.000802883073551
Crlc35 nrlc35_2 rlc5 1.37817071105e-14
* RLC[41] P2A-rlc11
Rrlc41 P2A nrlc41_1 65009.1016986
Lrlc41 nrlc41_1 nrlc41_2 0.00234962905389
Crlc41 nrlc41_2 rlc11 6.1774389826e-16
* RLC[42] P2A-rlc12
Rrlc42 P2A nrlc42_1 32861.0224416
Lrlc42 nrlc42_1 nrlc42_2 0.00525739322339
Crlc42 nrlc42_2 rlc12 5.40960814824e-15
* RLC[43] P2A-rlc13
Rrlc43 P2A nrlc43_1 84.4540151601
Lrlc43 nrlc43_1 nrlc43_2 2.66216201702e-06
Crlc43 nrlc43_2 rlc13 4.14716552456e-13
* RLC[47] P3A-P4A
Rrlc47 P3A nrlc47_1 8.57526490855
Lrlc47 nrlc47_1 nrlc47_2 1.03627334218e-06
Crlc47 nrlc47_2 P4A 8.49084513152e-08
* RLC[51] P3A-P4B
Rrlc51 P3A nrlc51_1 4.32322288397
Lrlc51 nrlc51_1 nrlc51_2 1.36093970674e-07
Crlc51 nrlc51_2 P4B 8.0906073264e-12
* RLC[53] P3A-rlc1
Rrlc53 P3A nrlc53_1 125.590773418
Lrlc53 nrlc53_1 nrlc53_2 4.59257065644e-06
Crlc53 nrlc53_2 rlc1 3.23517566615e-13
* RLC[58] P3A-rlc6
Rrlc58 P3A nrlc58_1 4282791.70947
Lrlc58 nrlc58_1 nrlc58_2 1
Crlc58 nrlc58_2 rlc6 1.34356966649e-14
* RLC[59] P3A-rlc7
Rrlc59 P3A nrlc59_1 31301010.6478
Lrlc59 nrlc59_1 nrlc59_2 0.0762831167691
Crlc59 nrlc59_2 rlc7 1.46396296476e-14
* RLC[64] P3A-rlc12
Rrlc64 P3A nrlc64_1 382419.903666
Lrlc64 nrlc64_1 nrlc64_2 1
Crlc64 nrlc64_2 rlc12 7.59760157544e-15
* RLC[65] P3A-rlc13
Rrlc65 P3A nrlc65_1 8466.40423966
Lrlc65 nrlc65_1 nrlc65_2 9.43111331168e-05
Crlc65 nrlc65_2 rlc13 3.00017508128e-13
* RLC[68] P3A-P1B
Rrlc68 P3A nrlc68_1 58039.1137068
Lrlc68 nrlc68_1 nrlc68_2 4.82220744781e-06
Crlc68 nrlc68_2 P1B 5.3035950299e-13
* RLC[76] P4A-rlc3
Rrlc76 P4A nrlc76_1 118389.209523
Lrlc76 nrlc76_1 nrlc76_2 0.00372952360925
Crlc76 nrlc76_2 rlc3 2.92011794335e-14
* RLC[78] P4A-rlc5
Rrlc78 P4A nrlc78_1 2287947.92383
Lrlc78 nrlc78_1 nrlc78_2 0.000133364862286
Crlc78 nrlc78_2 rlc5 2.23961591914e-13
* RLC[80] P4A-rlc7
Rrlc80 P4A nrlc80_1 3671042.08681
Lrlc80 nrlc80_1 nrlc80_2 0.808630640627
Crlc80 nrlc80_2 rlc7 3.16588008868e-14
* RLC[81] P4A-rlc8
Rrlc81 P4A nrlc81_1 0.01
Lrlc81 nrlc81_1 nrlc81_2 4.55934372125e-14
Crlc81 nrlc81_2 rlc8 9.2345327877e-12
* RLC[87] P4A-rlc14
Rrlc87 P4A nrlc87_1 10644735.9278
Lrlc87 nrlc87_1 nrlc87_2 0.0308846947943
Crlc87 nrlc87_2 rlc14 1.53432334275e-13
* RLC[90] P1B-P2B
Rrlc90 P1B nrlc90_1 0.218427318604
Lrlc90 nrlc90_1 nrlc90_2 1.95952937846e-07
Crlc90 nrlc90_2 P2B 2.04638388615e-05
* RLC[92] P1B-P4B
Rrlc92 P1B nrlc92_1 13.4057260557
Lrlc92 nrlc92_1 nrlc92_2 2.78827544711e-06
Crlc92 nrlc92_2 P4B 4.35315231449e-08
* RLC[94] P1B-rlc1
Rrlc94 P1B nrlc94_1 379.592470454
Lrlc94 nrlc94_1 nrlc94_2 1
Crlc94 nrlc94_2 rlc1 0.001
* RLC[100] P1B-rlc7
Rrlc100 P1B nrlc100_1 1.01017901136
Lrlc100 nrlc100_1 nrlc100_2 2.71365630523e-07
Crlc100 nrlc100_2 rlc7 2.13763388266e-06
* RLC[101] P1B-rlc8
Rrlc101 P1B nrlc101_1 8805083454.65
Lrlc101 nrlc101_1 nrlc101_2 0.00120538232167
Crlc101 nrlc101_2 rlc8 4.12965367862e-08
* RLC[102] P1B-rlc9
Rrlc102 P1B nrlc102_1 15747771592
Lrlc102 nrlc102_1 nrlc102_2 0.000173779193364
Crlc102 nrlc102_2 rlc9 1.94463841663e-07
* RLC[105] P1B-rlc12
Rrlc105 P1B nrlc105_1 608.998622797
Lrlc105 nrlc105_1 nrlc105_2 0.252940210534
Crlc105 nrlc105_2 rlc12 3.5010303406e-05
* RLC[106] P1B-rlc13
Rrlc106 P1B nrlc106_1 78.0115464343
Lrlc106 nrlc106_1 nrlc106_2 2.44531506666e-06
Crlc106 nrlc106_2 rlc13 5.09997504162e-10
* RLC[107] P1B-rlc14
Rrlc107 P1B nrlc107_1 768.339614533
Lrlc107 nrlc107_1 nrlc107_2 4.32708916375e-08
Crlc107 nrlc107_2 rlc14 2.43488280065e-10
* RLC[110] P2B-P3B
Rrlc110 P2B nrlc110_1 276.691578767
Lrlc110 nrlc110_1 nrlc110_2 1.53769983642e-08
Crlc110 nrlc110_2 P3B 2.98301116026e-09
* RLC[111] P2B-P4B
Rrlc111 P2B nrlc111_1 3626.71658077
Lrlc111 nrlc111_1 nrlc111_2 2.97187014862e-07
Crlc111 nrlc111_2 P4B 1.93603344232e-10
* RLC[113] P2B-rlc1
Rrlc113 P2B nrlc113_1 292.652000048
Lrlc113 nrlc113_1 nrlc113_2 0.00475006819223
Crlc113 nrlc113_2 rlc1 7.26059736695e-07
* RLC[114] P2B-rlc2
Rrlc114 P2B nrlc114_1 1098.42019951
Lrlc114 nrlc114_1 nrlc114_2 1.97842622308e-05
Crlc114 nrlc114_2 rlc2 1.81241072107e-10
* RLC[116] P2B-rlc4
Rrlc116 P2B nrlc116_1 238.230516176
Lrlc116 nrlc116_1 nrlc116_2 1.29951137423e-08
Crlc116 nrlc116_2 rlc4 5.78051810641e-09
* RLC[117] P2B-rlc5
Rrlc117 P2B nrlc117_1 26240180249.5
Lrlc117 nrlc117_1 nrlc117_2 1
Crlc117 nrlc117_2 rlc5 4.16401142482e-07
* RLC[118] P2B-rlc6
Rrlc118 P2B nrlc118_1 5.21750824291
Lrlc118 nrlc118_1 nrlc118_2 0.00375498404359
Crlc118 nrlc118_2 rlc6 1.53263697484e-07
* RLC[119] P2B-rlc7
Rrlc119 P2B nrlc119_1 0.01
Lrlc119 nrlc119_1 nrlc119_2 1.05470238239e-07
Crlc119 nrlc119_2 rlc7 7.48116484482e-06
* RLC[120] P2B-rlc8
Rrlc120 P2B nrlc120_1 15499363589.9
Lrlc120 nrlc120_1 nrlc120_2 1
Crlc120 nrlc120_2 rlc8 1.67437244302e-07
* RLC[121] P2B-rlc9
Rrlc121 P2B nrlc121_1 1820.16764207
Lrlc121 nrlc121_1 nrlc121_2 9.8651804576e-05
Crlc121 nrlc121_2 rlc9 3.13897015091e-11
* RLC[122] P2B-rlc10
Rrlc122 P2B nrlc122_1 9200.24059498
Lrlc122 nrlc122_1 nrlc122_2 0.0433261806836
Crlc122 nrlc122_2 rlc10 1.14555520699e-05
* RLC[123] P2B-rlc11
Rrlc123 P2B nrlc123_1 922.573129827
Lrlc123 nrlc123_1 nrlc123_2 1
Crlc123 nrlc123_2 rlc11 9.93153325253e-06
* RLC[124] P2B-rlc12
Rrlc124 P2B nrlc124_1 5775.35623113
Lrlc124 nrlc124_1 nrlc124_2 0.0371992450688
Crlc124 nrlc124_2 rlc12 0.000387193129398
* RLC[126] P2B-rlc14
Rrlc126 P2B nrlc126_1 80421.8323804
Lrlc126 nrlc126_1 nrlc126_2 4.15754096541e-06
Crlc126 nrlc126_2 rlc14 3.77139206788e-11
* RLC[128] P2B-P1B
Rrlc128 P2B nrlc128_1 6.65676686751
Lrlc128 nrlc128_1 nrlc128_2 7.11287725999e-07
Crlc128 nrlc128_2 P1B 2.07720406033e-07
* RLC[129] P3B-P4B
Rrlc129 P3B nrlc129_1 0.402955411257
Lrlc129 nrlc129_1 nrlc129_2 3.96356375557e-07
Crlc129 nrlc129_2 P4B 4.11403111275e-05
* RLC[130] P3B-rlc0
Rrlc130 P3B nrlc130_1 9.32495898031
Lrlc130 nrlc130_1 nrlc130_2 7.79959598286e-07
Crlc130 nrlc130_2 rlc0 6.99026539043e-11
* RLC[131] P3B-rlc1
Rrlc131 P3B nrlc131_1 396.657412483
Lrlc131 nrlc131_1 nrlc131_2 0.00520730692093
Crlc131 nrlc131_2 rlc1 6.69618433211e-06
* RLC[133] P3B-rlc3
Rrlc133 P3B nrlc133_1 15.5346940807
Lrlc133 nrlc133_1 nrlc133_2 7.47151425812e-07
Crlc133 nrlc133_2 rlc3 9.77348970219e-11
* RLC[134] P3B-rlc4
Rrlc134 P3B nrlc134_1 0.015822036616
Lrlc134 nrlc134_1 nrlc134_2 3.26258272187e-11
Crlc134 nrlc134_2 rlc4 3.01254522049e-07
* RLC[135] P3B-rlc5
Rrlc135 P3B nrlc135_1 26.7834176594
Lrlc135 nrlc135_1 nrlc135_2 1.04317872815e-06
Crlc135 nrlc135_2 rlc5 3.31818940843e-11
* RLC[136] P3B-rlc6
Rrlc136 P3B nrlc136_1 59.5552735668
Lrlc136 nrlc136_1 nrlc136_2 0.0247137722826
Crlc136 nrlc136_2 rlc6 3.01762119247e-05
* RLC[137] P3B-rlc7
Rrlc137 P3B nrlc137_1 0.541827076214
Lrlc137 nrlc137_1 nrlc137_2 6.48918665007e-09
Crlc137 nrlc137_2 rlc7 2.45598861333e-11
* RLC[138] P3B-rlc8
Rrlc138 P3B nrlc138_1 62963819074.4
Lrlc138 nrlc138_1 nrlc138_2 0.999994581428
Crlc138 nrlc138_2 rlc8 6.20983106919e-07
* RLC[139] P3B-rlc9
Rrlc139 P3B nrlc139_1 3757.58970737
Lrlc139 nrlc139_1 nrlc139_2 0.00197630900222
Crlc139 nrlc139_2 rlc9 1.5552264161e-13
* RLC[140] P3B-rlc10
Rrlc140 P3B nrlc140_1 74.4857022133
Lrlc140 nrlc140_1 nrlc140_2 1.59513894058e-06
Crlc140 nrlc140_2 rlc10 6.60635331639e-11
* RLC[142] P3B-rlc12
Rrlc142 P3B nrlc142_1 3373.99250955
Lrlc142 nrlc142_1 nrlc142_2 0.0153215453957
Crlc142 nrlc142_2 rlc12 0.001
* RLC[143] P3B-rlc13
Rrlc143 P3B nrlc143_1 121.734684203
Lrlc143 nrlc143_1 nrlc143_2 1.4352003139e-06
Crlc143 nrlc143_2 rlc13 1.55355675202e-11
* RLC[144] P3B-rlc14
Rrlc144 P3B nrlc144_1 106.315593773
Lrlc144 nrlc144_1 nrlc144_2 3.41640022003e-05
Crlc144 nrlc144_2 rlc14 3.35839901291e-12
* RLC[145] P3B-rlc15
Rrlc145 P3B nrlc145_1 15.6874724851
Lrlc145 nrlc145_1 nrlc145_2 5.23131465381e-07
Crlc145 nrlc145_2 rlc15 9.73952813104e-06
* RLC[146] P3B-P1B
Rrlc146 P3B nrlc146_1 3.82594433092
Lrlc146 nrlc146_1 nrlc146_2 4.8504603234e-06
Crlc146 nrlc146_2 P1B 1.29543577474e-06
* RLC[147] P4B-rlc0
Rrlc147 P4B nrlc147_1 380.709463091
Lrlc147 nrlc147_1 nrlc147_2 2.334847e-05
Crlc147 nrlc147_2 rlc0 8.51074803879e-12
* RLC[148] P4B-rlc1
Rrlc148 P4B nrlc148_1 0.463697805788
Lrlc148 nrlc148_1 nrlc148_2 0.00294823088071
Crlc148 nrlc148_2 rlc1 1.86742835983e-05
* RLC[149] P4B-rlc2
Rrlc149 P4B nrlc149_1 0.774637250517
Lrlc149 nrlc149_1 nrlc149_2 0.0137469025941
Crlc149 nrlc149_2 rlc2 0.000953710938559
* RLC[152] P4B-rlc5
Rrlc152 P4B nrlc152_1 12477.7591898
Lrlc152 nrlc152_1 nrlc152_2 0.0149054195798
Crlc152 nrlc152_2 rlc5 1.06372286974e-13
* RLC[153] P4B-rlc6
Rrlc153 P4B nrlc153_1 720.236044422
Lrlc153 nrlc153_1 nrlc153_2 3.82263367294e-05
Crlc153 nrlc153_2 rlc6 8.24196271163e-12
* RLC[154] P4B-rlc7
Rrlc154 P4B nrlc154_1 1.46430145709
Lrlc154 nrlc154_1 nrlc154_2 1.92679480575e-06
Crlc154 nrlc154_2 rlc7 8.44686889967e-06
* RLC[156] P4B-rlc9
Rrlc156 P4B nrlc156_1 919.826414795
Lrlc156 nrlc156_1 nrlc156_2 4.14460328229e-07
Crlc156 nrlc156_2 rlc9 2.85356490023e-10
* RLC[158] P4B-rlc11
Rrlc158 P4B nrlc158_1 45.6719240772
Lrlc158 nrlc158_1 nrlc158_2 1.69396162662e-06
Crlc158 nrlc158_2 rlc11 4.29990916416e-10
* RLC[161] P4B-rlc14
Rrlc161 P4B nrlc161_1 1951.58838308
Lrlc161 nrlc161_1 nrlc161_2 1.1721928333e-10
Crlc161 nrlc161_2 rlc14 2.30368125552e-10
* RLC[162] P4B-rlc15
Rrlc162 P4B nrlc162_1 20.7770188291
Lrlc162 nrlc162_1 nrlc162_2 1.21913765212e-06
Crlc162 nrlc162_2 rlc15 1.99852447476e-09
* RLC[164] rlc0-rlc1
Rrlc164 rlc0 nrlc164_1 66.111309216
Lrlc164 nrlc164_1 nrlc164_2 3.89191966229e-06
Crlc164 nrlc164_2 rlc1 9.15612597274e-08
* RLC[165] rlc0-rlc2
Rrlc165 rlc0 nrlc165_1 0.253057779408
Lrlc165 nrlc165_1 nrlc165_2 2.0383385832e-09
Crlc165 nrlc165_2 rlc2 2.25728742323e-09
* RLC[167] rlc0-rlc4
Rrlc167 rlc0 nrlc167_1 896.727051679
Lrlc167 nrlc167_1 nrlc167_2 0.0700071975485
Crlc167 nrlc167_2 rlc4 1.21115934874e-07
* RLC[168] rlc0-rlc5
Rrlc168 rlc0 nrlc168_1 123.94700974
Lrlc168 nrlc168_1 nrlc168_2 4.08338243923e-05
Crlc168 nrlc168_2 rlc5 6.30815173145e-12
* RLC[169] rlc0-rlc6
Rrlc169 rlc0 nrlc169_1 124.329176223
Lrlc169 nrlc169_1 nrlc169_2 0.00276091228671
Crlc169 nrlc169_2 rlc6 1.29972461146e-06
* RLC[170] rlc0-rlc7
Rrlc170 rlc0 nrlc170_1 3479.25408132
Lrlc170 nrlc170_1 nrlc170_2 0.996819810227
Crlc170 nrlc170_2 rlc7 4.3539104536e-05
* RLC[171] rlc0-rlc8
Rrlc171 rlc0 nrlc171_1 107.93096386
Lrlc171 nrlc171_1 nrlc171_2 4.63896808798e-05
Crlc171 nrlc171_2 rlc8 4.4247298948e-12
* RLC[173] rlc0-rlc10
Rrlc173 rlc0 nrlc173_1 1509.99840622
Lrlc173 nrlc173_1 nrlc173_2 0.989733377541
Crlc173 nrlc173_2 rlc10 8.06805955133e-05
* RLC[174] rlc0-rlc11
Rrlc174 rlc0 nrlc174_1 236.110784685
Lrlc174 nrlc174_1 nrlc174_2 1
Crlc174 nrlc174_2 rlc11 1.68163275422e-05
* RLC[175] rlc0-rlc12
Rrlc175 rlc0 nrlc175_1 19.5677807246
Lrlc175 nrlc175_1 nrlc175_2 0.445350753346
Crlc175 nrlc175_2 rlc12 4.65176802706e-05
* RLC[177] rlc0-rlc14
Rrlc177 rlc0 nrlc177_1 35.3977193884
Lrlc177 nrlc177_1 nrlc177_2 2.22753407239e-06
Crlc177 nrlc177_2 rlc14 3.37781301247e-11
* RLC[178] rlc0-rlc15
Rrlc178 rlc0 nrlc178_1 767.323879318
Lrlc178 nrlc178_1 nrlc178_2 0.0617618379608
Crlc178 nrlc178_2 rlc15 0.00011303414896
* RLC[180] rlc1-rlc2
Rrlc180 rlc1 nrlc180_1 1.09469762097
Lrlc180 nrlc180_1 nrlc180_2 2.82258113812e-07
Crlc180 nrlc180_2 rlc2 2.61707839495e-10
* RLC[181] rlc1-rlc3
Rrlc181 rlc1 nrlc181_1 128.059932733
Lrlc181 nrlc181_1 nrlc181_2 3.83333653263e-05
Crlc181 nrlc181_2 rlc3 2.59721498499e-12
* RLC[182] rlc1-rlc4
Rrlc182 rlc1 nrlc182_1 22.9553257096
Lrlc182 nrlc182_1 nrlc182_2 1.29260663863e-06
Crlc182 nrlc182_2 rlc4 5.67289503986e-11
* RLC[183] rlc1-rlc5
Rrlc183 rlc1 nrlc183_1 3.72777895323
Lrlc183 nrlc183_1 nrlc183_2 8.44080088823e-07
Crlc183 nrlc183_2 rlc5 6.74913953884e-11
* RLC[184] rlc1-rlc6
Rrlc184 rlc1 nrlc184_1 1022.96098393
Lrlc184 nrlc184_1 nrlc184_2 1.03174060222e-09
Crlc184 nrlc184_2 rlc6 1.41676022002e-07
* RLC[185] rlc1-rlc7
Rrlc185 rlc1 nrlc185_1 1203.00767557
Lrlc185 nrlc185_1 nrlc185_2 0.00897020487905
Crlc185 nrlc185_2 rlc7 8.88090842085e-10
* RLC[186] rlc1-rlc8
Rrlc186 rlc1 nrlc186_1 80554636454.7
Lrlc186 nrlc186_1 nrlc186_2 0.99987019429
Crlc186 nrlc186_2 rlc8 1.65196800402e-06
* RLC[188] rlc1-rlc10
Rrlc188 rlc1 nrlc188_1 682.803043008
Lrlc188 nrlc188_1 nrlc188_2 3.70383677898e-06
Crlc188 nrlc188_2 rlc10 3.86840207656e-12
* RLC[189] rlc1-rlc11
Rrlc189 rlc1 nrlc189_1 147.288852087
Lrlc189 nrlc189_1 nrlc189_2 7.09462981111e-06
Crlc189 nrlc189_2 rlc11 1.15490682914e-11
* RLC[192] rlc1-rlc14
Rrlc192 rlc1 nrlc192_1 37.9797220168
Lrlc192 nrlc192_1 nrlc192_2 3.67602667228e-06
Crlc192 nrlc192_2 rlc14 3.45716827279e-11
* RLC[195] rlc2-rlc3
Rrlc195 rlc2 nrlc195_1 2.50970021643
Lrlc195 nrlc195_1 nrlc195_2 3.30030868698e-07
Crlc195 nrlc195_2 rlc3 1.26004461778e-10
* RLC[196] rlc2-rlc4
Rrlc196 rlc2 nrlc196_1 181.20181756
Lrlc196 nrlc196_1 nrlc196_2 0.00875458470396
Crlc196 nrlc196_2 rlc4 5.50669194733e-08
* RLC[197] rlc2-rlc5
Rrlc197 rlc2 nrlc197_1 2.83913030633
Lrlc197 nrlc197_1 nrlc197_2 6.05881427813e-07
Crlc197 nrlc197_2 rlc5 8.35170650313e-11
* RLC[198] rlc2-rlc6
Rrlc198 rlc2 nrlc198_1 111.640804468
Lrlc198 nrlc198_1 nrlc198_2 1.00808431368e-12
Crlc198 nrlc198_2 rlc6 1.94040108844e-11
* RLC[199] rlc2-rlc7
Rrlc199 rlc2 nrlc199_1 1823.5973226
Lrlc199 nrlc199_1 nrlc199_2 0.0514000622727
Crlc199 nrlc199_2 rlc7 4.37872782941e-06
* RLC[200] rlc2-rlc8
Rrlc200 rlc2 nrlc200_1 3.06365529633
Lrlc200 nrlc200_1 nrlc200_2 5.79544337021e-07
Crlc200 nrlc200_2 rlc8 8.59443844688e-11
* RLC[201] rlc2-rlc9
Rrlc201 rlc2 nrlc201_1 3703.1863986
Lrlc201 nrlc201_1 nrlc201_2 1.63583747094e-06
Crlc201 nrlc201_2 rlc9 6.50702009754e-11
* RLC[204] rlc2-rlc12
Rrlc204 rlc2 nrlc204_1 1.75176128667
Lrlc204 nrlc204_1 nrlc204_2 4.02785783238e-08
Crlc204 nrlc204_2 rlc12 2.4834301896e-11
* RLC[209] rlc3-rlc4
Rrlc209 rlc3 nrlc209_1 721.599286737
Lrlc209 nrlc209_1 nrlc209_2 0.127687040967
Crlc209 nrlc209_2 rlc4 0.00025569677423
* RLC[210] rlc3-rlc5
Rrlc210 rlc3 nrlc210_1 2910.08400098
Lrlc210 nrlc210_1 nrlc210_2 0.00154915647347
Crlc210 nrlc210_2 rlc5 2.03255228505e-13
* RLC[213] rlc3-rlc8
Rrlc213 rlc3 nrlc213_1 66406.0166498
Lrlc213 nrlc213_1 nrlc213_2 1
Crlc213 nrlc213_2 rlc8 2.51966399795e-13
* RLC[214] rlc3-rlc9
Rrlc214 rlc3 nrlc214_1 857.277087886
Lrlc214 nrlc214_1 nrlc214_2 2.31719375712e-05
Crlc214 nrlc214_2 rlc9 1.87819162258e-11
* RLC[216] rlc3-rlc11
Rrlc216 rlc3 nrlc216_1 70.2755848674
Lrlc216 nrlc216_1 nrlc216_2 4.18360370375e-06
Crlc216 nrlc216_2 rlc11 1.23773744e-11
* RLC[219] rlc3-rlc14
Rrlc219 rlc3 nrlc219_1 79.4934078479
Lrlc219 nrlc219_1 nrlc219_2 2.27067990325e-05
Crlc219 nrlc219_2 rlc14 3.99255746799e-12
* RLC[220] rlc3-rlc15
Rrlc220 rlc3 nrlc220_1 536.500393023
Lrlc220 nrlc220_1 nrlc220_2 0.37381623197
Crlc220 nrlc220_2 rlc15 4.2357816248e-09
* RLC[222] rlc4-rlc5
Rrlc222 rlc4 nrlc222_1 10.5696339109
Lrlc222 nrlc222_1 nrlc222_2 4.18410710662e-07
Crlc222 nrlc222_2 rlc5 1.03753604099e-10
* RLC[224] rlc4-rlc7
Rrlc224 rlc4 nrlc224_1 113.013091707
Lrlc224 nrlc224_1 nrlc224_2 2.20008690808e-06
Crlc224 nrlc224_2 rlc7 1.72114150146e-10
* RLC[225] rlc4-rlc8
Rrlc225 rlc4 nrlc225_1 79.5106976072
Lrlc225 nrlc225_1 nrlc225_2 2.33081158141e-06
Crlc225 nrlc225_2 rlc8 2.7654678762e-11
* RLC[227] rlc4-rlc10
Rrlc227 rlc4 nrlc227_1 113.333231024
Lrlc227 nrlc227_1 nrlc227_2 2.08265214425e-06
Crlc227 nrlc227_2 rlc10 2.48337210134e-11
* RLC[228] rlc4-rlc11
Rrlc228 rlc4 nrlc228_1 42.0177766139
Lrlc228 nrlc228_1 nrlc228_2 1.96172870444e-07
Crlc228 nrlc228_2 rlc11 3.20122242917e-09
* RLC[229] rlc4-rlc12
Rrlc229 rlc4 nrlc229_1 62.2001824924
Lrlc229 nrlc229_1 nrlc229_2 7.47907447336e-07
Crlc229 nrlc229_2 rlc12 5.5251292844e-10
* RLC[230] rlc4-rlc13
Rrlc230 rlc4 nrlc230_1 8.39544825112
Lrlc230 nrlc230_1 nrlc230_2 3.87954559026e-07
Crlc230 nrlc230_2 rlc13 9.1683828154e-05
* RLC[231] rlc4-rlc14
Rrlc231 rlc4 nrlc231_1 94.3985850181
Lrlc231 nrlc231_1 nrlc231_2 2.69063511519e-08
Crlc231 nrlc231_2 rlc14 2.29824196958e-11
* RLC[233] rlc4-P1B
Rrlc233 rlc4 nrlc233_1 406.921839483
Lrlc233 nrlc233_1 nrlc233_2 7.02676619787e-09
Crlc233 nrlc233_2 P1B 5.22902776692e-10
* RLC[234] rlc5-rlc6
Rrlc234 rlc5 nrlc234_1 58547.0146341
Lrlc234 nrlc234_1 nrlc234_2 0.396100841389
Crlc234 nrlc234_2 rlc6 1.28396665667e-13
* RLC[235] rlc5-rlc7
Rrlc235 rlc5 nrlc235_1 340.806952417
Lrlc235 nrlc235_1 nrlc235_2 3.10406742861e-06
Crlc235 nrlc235_2 rlc7 4.97625058575e-11
* RLC[236] rlc5-rlc8
Rrlc236 rlc5 nrlc236_1 0.015506710145
Lrlc236 nrlc236_1 nrlc236_2 1.03123063856e-08
Crlc236 nrlc236_2 rlc8 7.26676636746e-08
* RLC[237] rlc5-rlc9
Rrlc237 rlc5 nrlc237_1 878163.022651
Lrlc237 nrlc237_1 nrlc237_2 0.960110287091
Crlc237 nrlc237_2 rlc9 0.001
* RLC[238] rlc5-rlc10
Rrlc238 rlc5 nrlc238_1 1018.05012703
Lrlc238 nrlc238_1 nrlc238_2 2.27811211859e-06
Crlc238 nrlc238_2 rlc10 1.29235627236e-11
* RLC[239] rlc5-rlc11
Rrlc239 rlc5 nrlc239_1 100.647592772
Lrlc239 nrlc239_1 nrlc239_2 2.95080908174e-05
Crlc239 nrlc239_2 rlc11 3.23662077683e-12
* RLC[240] rlc5-rlc12
Rrlc240 rlc5 nrlc240_1 14351.2833441
Lrlc240 nrlc240_1 nrlc240_2 0.0386037724035
Crlc240 nrlc240_2 rlc12 3.27840873724e-11
* RLC[241] rlc5-rlc13
Rrlc241 rlc5 nrlc241_1 2496034546.49
Lrlc241 nrlc241_1 nrlc241_2 0.999992786426
Crlc241 nrlc241_2 rlc13 7.26385400003e-08
* RLC[242] rlc5-rlc14
Rrlc242 rlc5 nrlc242_1 663.876440216
Lrlc242 nrlc242_1 nrlc242_2 0.0011825804014
Crlc242 nrlc242_2 rlc14 9.93357746284e-07
* RLC[244] rlc5-P1B
Rrlc244 rlc5 nrlc244_1 24763.9374694
Lrlc244 nrlc244_1 nrlc244_2 8.30545366898e-06
Crlc244 nrlc244_2 P1B 1.13043475757e-10
* RLC[245] rlc6-rlc7
Rrlc245 rlc6 nrlc245_1 202.865349394
Lrlc245 nrlc245_1 nrlc245_2 2.32046094947e-06
Crlc245 nrlc245_2 rlc7 2.28425271724e-11
* RLC[246] rlc6-rlc8
Rrlc246 rlc6 nrlc246_1 5.09714413078
Lrlc246 nrlc246_1 nrlc246_2 1.09616542329e-12
Crlc246 nrlc246_2 rlc8 9.58193109489e-11
* RLC[247] rlc6-rlc9
Rrlc247 rlc6 nrlc247_1 18779.1278162
Lrlc247 nrlc247_1 nrlc247_2 0.776550503105
Crlc247 nrlc247_2 rlc9 2.6037562293e-12
* RLC[249] rlc6-rlc11
Rrlc249 rlc6 nrlc249_1 2.24195392421
Lrlc249 nrlc249_1 nrlc249_2 6.48957889403e-07
Crlc249 nrlc249_2 rlc11 1.5058789137e-08
* RLC[250] rlc6-rlc12
Rrlc250 rlc6 nrlc250_1 59.6287996
Lrlc250 nrlc250_1 nrlc250_2 5.03497232008e-12
Crlc250 nrlc250_2 rlc12 3.68773328755e-12
* RLC[252] rlc6-rlc14
Rrlc252 rlc6 nrlc252_1 190.871543909
Lrlc252 nrlc252_1 nrlc252_2 1.2529742944e-05
Crlc252 nrlc252_2 rlc14 9.06566480738e-12
* RLC[254] rlc6-P1B
Rrlc254 rlc6 nrlc254_1 4045.88548574
Lrlc254 nrlc254_1 nrlc254_2 0.000291227859553
Crlc254 nrlc254_2 P1B 5.36973829335e-07
* RLC[255] rlc7-rlc8
Rrlc255 rlc7 nrlc255_1 74109.705699
Lrlc255 nrlc255_1 nrlc255_2 0.000308567369261
Crlc255 nrlc255_2 rlc8 6.05233147929e-12
* RLC[256] rlc7-rlc9
Rrlc256 rlc7 nrlc256_1 98024.8664474
Lrlc256 nrlc256_1 nrlc256_2 0.000934668128911
Crlc256 nrlc256_2 rlc9 4.43676117187e-12
* RLC[259] rlc7-rlc12
Rrlc259 rlc7 nrlc259_1 0.305448884574
Lrlc259 nrlc259_1 nrlc259_2 2.33831640196e-08
Crlc259 nrlc259_2 rlc12 2.78473375736e-10
* RLC[260] rlc7-rlc13
Rrlc260 rlc7 nrlc260_1 0.0452399329553
Lrlc260 nrlc260_1 nrlc260_2 3.64034297726e-10
Crlc260 nrlc260_2 rlc13 1.91596923451e-07
* RLC[261] rlc7-rlc14
Rrlc261 rlc7 nrlc261_1 139.777962699
Lrlc261 nrlc261_1 nrlc261_2 3.71098785902e-06
Crlc261 nrlc261_2 rlc14 2.46907873442e-11
* RLC[262] rlc7-rlc15
Rrlc262 rlc7 nrlc262_1 3.70208054171
Lrlc262 nrlc262_1 nrlc262_2 1.01554375341e-07
Crlc262 nrlc262_2 rlc15 8.23311921182e-12
* RLC[264] rlc8-rlc9
Rrlc264 rlc8 nrlc264_1 172.92137179
Lrlc264 nrlc264_1 nrlc264_2 1.08568015781e-06
Crlc264 nrlc264_2 rlc9 1.48917252526e-11
* RLC[265] rlc8-rlc10
Rrlc265 rlc8 nrlc265_1 1.94855301402
Lrlc265 nrlc265_1 nrlc265_2 9.5322848612e-08
Crlc265 nrlc265_2 rlc10 2.78958011127e-11
* RLC[266] rlc8-rlc11
Rrlc266 rlc8 nrlc266_1 20.4883163416
Lrlc266 nrlc266_1 nrlc266_2 6.21260748583e-07
Crlc266 nrlc266_2 rlc11 6.25964337344e-11
* RLC[267] rlc8-rlc12
Rrlc267 rlc8 nrlc267_1 2474.00058117
Lrlc267 nrlc267_1 nrlc267_2 4.38879781572e-08
Crlc267 nrlc267_2 rlc12 3.87710614898e-11
* RLC[268] rlc8-rlc13
Rrlc268 rlc8 nrlc268_1 111.161103084
Lrlc268 nrlc268_1 nrlc268_2 8.34756554068e-07
Crlc268 nrlc268_2 rlc13 3.28063996656e-11
* RLC[269] rlc8-rlc14
Rrlc269 rlc8 nrlc269_1 838.720968725
Lrlc269 nrlc269_1 nrlc269_2 8.49426560334e-06
Crlc269 nrlc269_2 rlc14 4.04019197685e-09
* RLC[270] rlc8-rlc15
Rrlc270 rlc8 nrlc270_1 127666552.924
Lrlc270 nrlc270_1 nrlc270_2 0.999989755617
Crlc270 nrlc270_2 rlc15 8.94511479658e-05
* RLC[271] rlc8-P1B
Rrlc271 rlc8 nrlc271_1 4286.97581051
Lrlc271 nrlc271_1 nrlc271_2 8.99719885802e-05
Crlc271 nrlc271_2 P1B 1.02570969253e-10
* RLC[273] rlc9-rlc11
Rrlc273 rlc9 nrlc273_1 675.154492963
Lrlc273 nrlc273_1 nrlc273_2 1.53182975304e-05
Crlc273 nrlc273_2 rlc11 1.28810464069e-11
* RLC[274] rlc9-rlc12
Rrlc274 rlc9 nrlc274_1 0.0111537358622
Lrlc274 nrlc274_1 nrlc274_2 1.01319050579e-11
Crlc274 nrlc274_2 rlc12 9.04915856709e-11
* RLC[275] rlc9-rlc13
Rrlc275 rlc9 nrlc275_1 171.851162451
Lrlc275 nrlc275_1 nrlc275_2 1.21178181119e-06
Crlc275 nrlc275_2 rlc13 4.43387235178e-11
* RLC[276] rlc9-rlc14
Rrlc276 rlc9 nrlc276_1 150.508190349
Lrlc276 nrlc276_1 nrlc276_2 1.21419887054e-05
Crlc276 nrlc276_2 rlc14 2.71843453275e-08
* RLC[278] rlc9-P1B
Rrlc278 rlc9 nrlc278_1 2197.94238432
Lrlc278 nrlc278_1 nrlc278_2 0.000179056346463
Crlc278 nrlc278_2 P1B 4.11826796429e-14
* RLC[280] rlc10-rlc12
Rrlc280 rlc10 nrlc280_1 2253.25707214
Lrlc280 nrlc280_1 nrlc280_2 0.00072026956349
Crlc280 nrlc280_2 rlc12 5.86921506148e-10
* RLC[281] rlc10-rlc13
Rrlc281 rlc10 nrlc281_1 109.894286613
Lrlc281 nrlc281_1 nrlc281_2 2.49108475062e-06
Crlc281 nrlc281_2 rlc13 5.21477095357e-11
* RLC[282] rlc10-rlc14
Rrlc282 rlc10 nrlc282_1 11639.7316045
Lrlc282 nrlc282_1 nrlc282_2 0.010968162438
Crlc282 nrlc282_2 rlc14 8.69173770682e-12
* RLC[284] rlc10-P1B
Rrlc284 rlc10 nrlc284_1 923.652374218
Lrlc284 nrlc284_1 nrlc284_2 1
Crlc284 nrlc284_2 P1B 0.000259021728203
* RLC[286] rlc11-rlc13
Rrlc286 rlc11 nrlc286_1 3485.93103624
Lrlc286 nrlc286_1 nrlc286_2 0.352419110303
Crlc286 nrlc286_2 rlc13 4.26340472605e-08
* RLC[287] rlc11-rlc14
Rrlc287 rlc11 nrlc287_1 7185580709.31
Lrlc287 nrlc287_1 nrlc287_2 0.982090093924
Crlc287 nrlc287_2 rlc14 0.000710046404524
* RLC[288] rlc11-rlc15
Rrlc288 rlc11 nrlc288_1 35.1161981211
Lrlc288 nrlc288_1 nrlc288_2 1.55682505256e-06
Crlc288 nrlc288_2 rlc15 8.14317871703e-11
* RLC[289] rlc11-P1B
Rrlc289 rlc11 nrlc289_1 366.688462298
Lrlc289 nrlc289_1 nrlc289_2 2.75370001538e-05
Crlc289 nrlc289_2 P1B 3.86650273421e-10
* RLC[290] rlc12-rlc13
Rrlc290 rlc12 nrlc290_1 182.912476369
Lrlc290 nrlc290_1 nrlc290_2 6.19229250801e-05
Crlc290 nrlc290_2 rlc13 1.83765216678e-07
* RLC[294] rlc13-rlc14
Rrlc294 rlc13 nrlc294_1 212.914051314
Lrlc294 nrlc294_1 nrlc294_2 2.2546331454e-05
Crlc294 nrlc294_2 rlc14 6.94564960759e-12
* RLC[297] rlc14-rlc15
Rrlc297 rlc14 nrlc297_1 1831095536.02
Lrlc297 nrlc297_1 nrlc297_2 1
Crlc297 nrlc297_2 rlc15 2.5383653237e-06
* DC[0] P1A-P2A
Rdc0 P1A ndc0_1 0.0113931036773
Ldc0 ndc0_1 P2A 2.73706864925e-08
* DC[23] P3A-P4A
Rdc23 P3A ndc23_1 0.01
Ldc23 ndc23_1 P4A 9.96121071598e-08
* DC[42] P1B-P2B
Rdc42 P1B ndc42_1 0.0766497721346
Ldc42 ndc42_1 P2B 2.55897175893e-07
* DC[46] P1B-dc1
Rdc46 P1B ndc46_1 0.01
Ldc46 ndc46_1 dc1 0.000696525209244
* DC[47] P1B-dc2
Rdc47 P1B ndc47_1 0.0120118925493
Ldc47 ndc47_1 dc2 0.000157739710126
* DC[50] P2B-P3B
Rdc50 P2B ndc50_1 1198.63155499
Ldc50 ndc50_1 P3B 0.000229472768455
* DC[53] P2B-dc1
Rdc53 P2B ndc53_1 5.24531273839
Ldc53 ndc53_1 dc1 8.34837756947e-07
* DC[54] P2B-dc2
Rdc54 P2B ndc54_1 5.43774476507
Ldc54 ndc54_1 dc2 0.00012927901396
* DC[57] P3B-P4B
Rdc57 P3B ndc57_1 0.203434882785
Ldc57 ndc57_1 P4B 7.53963647567e-08
* DC[59] P3B-dc1
Rdc59 P3B ndc59_1 15.7836027086
Ldc59 ndc59_1 dc1 3.32534164622e-06
* DC[60] P3B-dc2
Rdc60 P3B ndc60_1 0.0102986363288
Ldc60 ndc60_1 dc2 4.39666173248e-06
* DC[61] P3B-dc3
Rdc61 P3B ndc61_1 1.86211854384
Ldc61 ndc61_1 dc3 2.96365370876e-07
* DC[62] P3B-P1B
Rdc62 P3B ndc62_1 1.37798611224
Ldc62 ndc62_1 P1B 0.000126385490361
* DC[63] P4B-dc0
Rdc63 P4B ndc63_1 0.0242234364165
Ldc63 ndc63_1 dc0 0.000313779474362
* DC[64] P4B-dc1
Rdc64 P4B ndc64_1 34.68531711
Ldc64 ndc64_1 dc1 0.000571564387402
* DC[65] P4B-dc2
Rdc65 P4B ndc65_1 0.28907507255
Ldc65 ndc65_1 dc2 1.23170387505e-07
* DC[67] P4B-P1B
Rdc67 P4B ndc67_1 124.959757798
Ldc67 ndc67_1 P1B 0.00214431122476
* DC[68] dc0-dc1
Rdc68 dc0 ndc68_1 19.215955489
Ldc68 ndc68_1 dc1 3.05831430231e-06
* DC[72] dc1-dc2
Rdc72 dc1 ndc72_1 0.0106874856399
Ldc72 ndc72_1 dc2 0.000282928655841
* DC[73] dc1-dc3
Rdc73 dc1 ndc73_1 0.01
Ldc73 ndc73_1 dc3 0.000559757120802
* DC[75] dc2-dc3
Rdc75 dc2 ndc75_1 0.0120038701523
Ldc75 ndc75_1 dc3 0.00010863853066
* DC[77] dc3-P1B
Rdc77 dc3 ndc77_1 0.0100000621488
Ldc77 ndc77_1 P1B 3.08084453097e-06
* ---- leaks
Rleak_P1A P1A P1B 1e+12
Rleak_P2A P2A P1B 1e+12
Rleak_P2B P2B P1B 1e+12
Rleak_P3A P3A P1B 1e+12
Rleak_P3B P3B P1B 1e+12
Rleak_P4A P4A P1B 1e+12
Rleak_P4B P4B P1B 1e+12
Rleak_dc0 dc0 P1B 1e+12
Rleak_dc1 dc1 P1B 1e+12
Rleak_dc2 dc2 P1B 1e+12
Rleak_dc3 dc3 P1B 1e+12
Rleak_rlc0 rlc0 P1B 1e+12
Rleak_rlc1 rlc1 P1B 1e+12
Rleak_rlc10 rlc10 P1B 1e+12
Rleak_rlc11 rlc11 P1B 1e+12
Rleak_rlc12 rlc12 P1B 1e+12
Rleak_rlc13 rlc13 P1B 1e+12
Rleak_rlc14 rlc14 P1B 1e+12
Rleak_rlc15 rlc15 P1B 1e+12
Rleak_rlc2 rlc2 P1B 1e+12
Rleak_rlc3 rlc3 P1B 1e+12
Rleak_rlc4 rlc4 P1B 1e+12
Rleak_rlc5 rlc5 P1B 1e+12
Rleak_rlc6 rlc6 P1B 1e+12
Rleak_rlc7 rlc7 P1B 1e+12
Rleak_rlc8 rlc8 P1B 1e+12
Rleak_rlc9 rlc9 P1B 1e+12
.ends fitted
