* fitted: 4-port fitted model, reference z0 = 50 Ohm
* port p is PpA (+) to PpB (-); the reference node is P1B
.subckt fitted P1A P1B P2A P2B P3A P3B P4A P4B
* ---- branches
* RLC[4] P1A-P2B
Rrlc4 P1A nrlc4_1 89146.8233654
Lrlc4 nrlc4_1 nrlc4_2 0.0281446429422
Crlc4 nrlc4_2 P2B 3.93497057744e-15
* RLC[5] P1A-P3B
Rrlc5 P1A nrlc5_1 3737916.30653
Lrlc5 nrlc5_1 nrlc5_2 0.0226938168397
Crlc5 nrlc5_2 P3B 2.36061990101e-13
* RLC[12] P1A-rlc5
Rrlc12 P1A nrlc12_1 4246.24337967
Lrlc12 nrlc12_1 nrlc12_2 0.000135470684028
Crlc12 nrlc12_2 rlc5 8.3482039152e-15
* RLC[14] P1A-rlc7
Rrlc14 P1A nrlc14_1 298498.083828
Lrlc14 nrlc14_1 nrlc14_2 0.00193998599197
Crlc14 nrlc14_2 rlc7 2.93442908146e-13
* RLC[18] P1A-rlc11
Rrlc18 P1A nrlc18_1 1223.07120099
Lrlc18 nrlc18_1 nrlc18_2 3.95058672314e-05
Crlc18 nrlc18_2 rlc11 2.9343749736e-14
* RLC[19] P1A-rlc12
Rrlc19 P1A nrlc19_1 0.17867323769
Lrlc19 nrlc19_1 nrlc19_2 1.63250425397e-10
Crlc19 nrlc19_2 rlc12 5.68188968776e-12
* RLC[21] P1A-rlc14
Rrlc21 P1A nrlc21_1 522.49340941
Lrlc21 nrlc21_1 nrlc21_2 1.66156764966e-06
Crlc21 nrlc21_2 rlc14 6.66824664255e-13
* RLC[25] P2A-P4A
Rrlc25 P2A nrlc25_1 2621.63311346
Lrlc25 nrlc25_1 nrlc25_2 6.86206985176e-05
Crlc25 nrlc25_2 P4A 2.45446109766e-14
* RLC[26] P2A-P1B
Rrlc26 P2A nrlc26_1 670342972250
Lrlc26 nrlc26_1 nrlc26_2 0.995631388429
Crlc26 nrlc26_2 P1B 1.1692421987e-10
* RLC[27] P2A-P2B
Rrlc27 P2A nrlc27_1 7777.29044062
Lrlc27 nrlc27_1 nrlc27_2 0.00109976393704
Crlc27 nrlc27_2 P2B 2.02022773568e-14
* RLC[30] P2A-rlc0
Rrlc30 P2A nrlc30_1 621.580048016
Lrlc30 nrlc30_1 nrlc30_2 1.23984052544e-13
Crlc30 nrlc30_2 rlc0 7.35160009419e-13
* RLC[33] P2A-rlc3
Rrlc33 P2A nrlc33_1 35.595065586
Lrlc33 nrlc33_1 nrlc33_2 1.41664394027e-06
Crlc33 nrlc33_2 rlc3 1.2423346658e-12
* RLC[34] P2A-rlc4
Rrlc34 P2A nrlc34_1 103530425391
Lrlc34 nrlc34_1 nrlc34_2 0.995268528646
Crlc34 nrlc34_2 rlc4 1.60355460944e-08
* RLC[36] P2A-rlc6
Rrlc36 P2A nrlc36_1 15.3647924399
Lrlc36 nrlc36_1 nrlc36_2 6.1375969164e-07
Crlc36 nrlc36_2 rlc6 2.88870010932e-12
* RLC[39] P2A-rlc9
Rrlc39 P2A nrlc39_1 2608.83533726
Lrlc39 nrlc39_1 nrlc39_2 0.00010831063531
Crlc39 nrlc39_2 rlc9 1.76821575924e-14
* RLC[41] P2A-rlc11
Rrlc41 P2A nrlc41_1 16797.5953622
Lrlc41 nrlc41_1 nrlc41_2 8.50001751757e-05
Crlc41 nrlc41_2 rlc11 4.03868089415e-13
* RLC[50] P3A-P3B
Rrlc50 P3A nrlc50_1 27.3416525061
Lrlc50 nrlc50_1 nrlc50_2 1.23234417712e-06
Crlc50 nrlc50_2 P3B 1.83163945116e-12
* RLC[52] P3A-rlc0
Rrlc52 P3A nrlc52_1 8.70741125361
Lrlc52 nrlc52_1 nrlc52_2 3.29152455874e-07
Crlc52 nrlc52_2 rlc0 4.82365764739e-12
* RLC[54] P3A-rlc2
Rrlc54 P3A nrlc54_1 786323.416778
Lrlc54 nrlc54_1 nrlc54_2 3.46147060492e-07
Crlc54 nrlc54_2 rlc2 2.22199569293e-13
* RLC[56] P3A-rlc4
Rrlc56 P3A nrlc56_1 300997490241
Lrlc56 nrlc56_1 nrlc56_2 0.986998390721
Crlc56 nrlc56_2 rlc4 8.17722097802e-10
* RLC[60] P3A-rlc8
Rrlc60 P3A nrlc60_1 11637.4781121
Lrlc60 nrlc60_1 nrlc60_2 0.00331437296709
Crlc60 nrlc60_2 rlc8 2.71919976672e-14
* RLC[63] P3A-rlc11
Rrlc63 P3A nrlc63_1 547593131279
Lrlc63 nrlc63_1 nrlc63_2 0.979320498094
Crlc63 nrlc63_2 rlc11 5.22283630817e-10
* RLC[64] P3A-rlc12
Rrlc64 P3A nrlc64_1 2712569.56741
Lrlc64 nrlc64_1 nrlc64_2 0.00736670878177
Crlc64 nrlc64_2 rlc12 3.50860037205e-13
* RLC[65] P3A-rlc13
Rrlc65 P3A nrlc65_1 6535.84552204
Lrlc65 nrlc65_1 nrlc65_2 0.000128704102742
Crlc65 nrlc65_2 rlc13 2.00546614163e-13
* RLC[66] P3A-rlc14
Rrlc66 P3A nrlc66_1 1712.75173885
Lrlc66 nrlc66_1 nrlc66_2 0.000189773493537
Crlc66 nrlc66_2 rlc14 7.18793612183e-14
* RLC[69] P4A-P1B
Rrlc69 P4A nrlc69_1 5197.49273658
Lrlc69 nrlc69_1 nrlc69_2 0.00103581486154
Crlc69 nrlc69_2 P1B 4.26041442284e-14
* RLC[72] P4A-P4B
Rrlc72 P4A nrlc72_1 668867.765506
Lrlc72 nrlc72_1 nrlc72_2 0.0329160503836
Crlc72 nrlc72_2 P4B 1.30624543465e-13
* RLC[79] P4A-rlc6
Rrlc79 P4A nrlc79_1 1875.44129276
Lrlc79 nrlc79_1 nrlc79_2 0.000233429029978
Crlc79 nrlc79_2 rlc6 7.37403862426e-14
* RLC[80] P4A-rlc7
Rrlc80 P4A nrlc80_1 21467.8775952
Lrlc80 nrlc80_1 nrlc80_2 0.00679996054206
Crlc80 nrlc80_2 rlc7 1.63940276207e-14
* RLC[81] P4A-rlc8
Rrlc81 P4A nrlc81_1 6.03585733301
Lrlc81 nrlc81_1 nrlc81_2 1.65111797699e-07
Crlc81 nrlc81_2 rlc8 5.03567466742e-12
* RLC[83] P4A-rlc10
Rrlc83 P4A nrlc83_1 1526.87921851
Lrlc83 nrlc83_1 nrlc83_2 4.82261837588e-13
Crlc83 nrlc83_2 rlc10 1.31110117024e-13
* RLC[85] P4A-rlc12
Rrlc85 P4A nrlc85_1 13313.2760342
Lrlc85 nrlc85_1 nrlc85_2 4.38038238344e-05
Crlc85 nrlc85_2 rlc12 8.99433252874e-13
* RLC[87] P4A-rlc14
Rrlc87 P4A nrlc87_1 6.99961425589
Lrlc87 nrlc87_1 nrlc87_2 2.2303602853e-07
Crlc87 nrlc87_2 rlc14 5.05806376287e-12
* RLC[89] P4A-P1B
Rrlc89 P4A nrlc89_1 378279822388
Lrlc89 nrlc89_1 nrlc89_2 1.19539784777e-07
Crlc89 nrlc89_2 P1B 2.8568109728e-10
* RLC[90] P1B-P2B
Rrlc90 P1B nrlc90_1 1.47818237443
Lrlc90 nrlc90_1 nrlc90_2 3.2735589033e-06
Crlc90 nrlc90_2 P2B 0.000272149401406
* RLC[91] P1B-P3B
Rrlc91 P1B nrlc91_1 135.810807739
Lrlc91 nrlc91_1 nrlc91_2 6.70368325447e-06
Crlc91 nrlc91_2 P3B 9.06234137496e-11
* RLC[92] P1B-P4B
Rrlc92 P1B nrlc92_1 71.4812571166
Lrlc92 nrlc92_1 nrlc92_2 1.97878002932e-05
Crlc92 nrlc92_2 P4B 3.80706909738e-09
* RLC[93] P1B-rlc0
Rrlc93 P1B nrlc93_1 59.5328503371
Lrlc93 nrlc93_1 nrlc93_2 0.00257436415937
Crlc93 nrlc93_2 rlc0 0.001
* RLC[94] P1B-rlc1
Rrlc94 P1B nrlc94_1 32.8784603188
Lrlc94 nrlc94_1 nrlc94_2 4.66492951364e-06
Crlc94 nrlc94_2 rlc1 4.79490087525e-12
* RLC[95] P1B-rlc2
Rrlc95 P1B nrlc95_1 0.129509823817
Lrlc95 nrlc95_1 nrlc95_2 1.29434157715e-07
Crlc95 nrlc95_2 rlc2 1.13287658064e-07
* RLC[97] P1B-rlc4
Rrlc97 P1B nrlc97_1 14.0955616773
Lrlc97 nrlc97_1 nrlc97_2 2.31484805445e-07
Crlc97 nrlc97_2 rlc4 6.70811867269e-08
* RLC[98] P1B-rlc5
Rrlc98 P1B nrlc98_1 21.08888849
Lrlc98 nrlc98_1 nrlc98_2 2.97649066962e-07
Crlc98 nrlc98_2 rlc5 3.06964771713e-09
* RLC[99] P1B-rlc6
Rrlc99 P1B nrlc99_1 5.71628218115
Lrlc99 nrlc99_1 nrlc99_2 2.19425443556e-06
Crlc99 nrlc99_2 rlc6 7.46134560609e-11
* RLC[100] P1B-rlc7
Rrlc100 P1B nrlc100_1 2.6406237382
Lrlc100 nrlc100_1 nrlc100_2 1.55293244301e-07
Crlc100 nrlc100_2 rlc7 2.47455441004e-11
* RLC[103] P1B-rlc10
Rrlc103 P1B nrlc103_1 2.76534283146
Lrlc103 nrlc103_1 nrlc103_2 4.58671513386e-07
Crlc103 nrlc103_2 rlc10 6.66440372143e-11
* RLC[105] P1B-rlc12
Rrlc105 P1B nrlc105_1 118.518010422
Lrlc105 nrlc105_1 nrlc105_2 4.34921644654e-10
Crlc105 nrlc105_2 rlc12 1.15112913629e-11
* RLC[106] P1B-rlc13
Rrlc106 P1B nrlc106_1 0.135769133554
Lrlc106 nrlc106_1 nrlc106_2 5.0795307301e-08
Crlc106 nrlc106_2 rlc13 3.06181530575e-09
* RLC[107] P1B-rlc14
Rrlc107 P1B nrlc107_1 20.3098787916
Lrlc107 nrlc107_1 nrlc107_2 3.13237814528e-06
Crlc107 nrlc107_2 rlc14 3.8721541538e-11
* RLC[110] P2B-P3B
Rrlc110 P2B nrlc110_1 14.2504272264
Lrlc110 nrlc110_1 nrlc110_2 1.64277528116e-07
Crlc110 nrlc110_2 P3B 8.65859121816e-08
* RLC[113] P2B-rlc1
Rrlc113 P2B nrlc113_1 6.8574398121
Lrlc113 nrlc113_1 nrlc113_2 7.10107033304e-07
Crlc113 nrlc113_2 rlc1 3.58617372643e-10
* RLC[114] P2B-rlc2
Rrlc114 P2B nrlc114_1 1.89138951788
Lrlc114 nrlc114_1 nrlc114_2 5.85415288119e-08
Crlc114 nrlc114_2 rlc2 0.000142768128325
* RLC[115] P2B-rlc3
Rrlc115 P2B nrlc115_1 21.451317864
Lrlc115 nrlc115_1 nrlc115_2 7.65796752594e-07
Crlc115 nrlc115_2 rlc3 1.88843599633e-10
* RLC[116] P2B-rlc4
Rrlc116 P2B nrlc116_1 9.77214814265
Lrlc116 nrlc116_1 nrlc116_2 2.73375059104e-06
Crlc116 nrlc116_2 rlc4 3.18079951331e-11
* RLC[117] P2B-rlc5
Rrlc117 P2B nrlc117_1 23.4039403801
Lrlc117 nrlc117_1 nrlc117_2 3.8388563856e-07
Crlc117 nrlc117_2 rlc5 1.54459576959e-10
* RLC[118] P2B-rlc6
Rrlc118 P2B nrlc118_1 62.9894888422
Lrlc118 nrlc118_1 nrlc118_2 1.71031831255e-05
Crlc118 nrlc118_2 rlc6 4.78958922578e-12
* RLC[119] P2B-rlc7
Rrlc119 P2B nrlc119_1 85.6026601511
Lrlc119 nrlc119_1 nrlc119_2 1.70490286329e-06
Crlc119 nrlc119_2 rlc7 1.22496204837e-11
* RLC[120] P2B-rlc8
Rrlc120 P2B nrlc120_1 8.68857395028
Lrlc120 nrlc120_1 nrlc120_2 2.2491295483e-06
Crlc120 nrlc120_2 rlc8 3.49059153167e-07
* RLC[121] P2B-rlc9
Rrlc121 P2B nrlc121_1 10.5936676291
Lrlc121 nrlc121_1 nrlc121_2 1.11043503163e-07
Crlc121 nrlc121_2 rlc9 9.78304909308e-09
* RLC[122] P2B-rlc10
Rrlc122 P2B nrlc122_1 19.6204866202
Lrlc122 nrlc122_1 nrlc122_2 1.45208318e-07
Crlc122 nrlc122_2 rlc10 2.2646423804e-10
* RLC[123] P2B-rlc11
Rrlc123 P2B nrlc123_1 1.47910574531
Lrlc123 nrlc123_1 nrlc123_2 0.000475853269971
Crlc123 nrlc123_2 rlc11 0.000974235612684
* RLC[124] P2B-rlc12
Rrlc124 P2B nrlc124_1 28.2844566651
Lrlc124 nrlc124_1 nrlc124_2 8.44038755114e-07
Crlc124 nrlc124_2 rlc12 1.17728003282e-10
* RLC[125] P2B-rlc13
Rrlc125 P2B nrlc125_1 0.921466824289
Lrlc125 nrlc125_1 nrlc125_2 2.94245291102e-08
Crlc125 nrlc125_2 rlc13 0.001
* RLC[126] P2B-rlc14
Rrlc126 P2B nrlc126_1 149.126576043
Lrlc126 nrlc126_1 nrlc126_2 5.18674134078e-06
Crlc126 nrlc126_2 rlc14 8.84937263729e-12
* RLC[127] P2B-rlc15
Rrlc127 P2B nrlc127_1 28.0372110222
Lrlc127 nrlc127_1 nrlc127_2 2.13215565151e-13
Crlc127 nrlc127_2 rlc15 1.92343272935e-11
* RLC[128] P2B-P1B
Rrlc128 P2B nrlc128_1 42.7763855492
Lrlc128 nrlc128_1 nrlc128_2 3.31743911403e-06
Crlc128 nrlc128_2 P1B 1.66347238049e-11
* RLC[129] P3B-P4B
Rrlc129 P3B nrlc129_1 4.82407860283
Lrlc129 nrlc129_1 nrlc129_2 1.10928780496e-05
Crlc129 nrlc129_2 P4B 4.58359841766e-06
* RLC[130] P3B-rlc0
Rrlc130 P3B nrlc130_1 0.0417341493279
Lrlc130 nrlc130_1 nrlc130_2 5.04824187544e-05
Crlc130 nrlc130_2 rlc0 0.001
* RLC[132] P3B-rlc2
Rrlc132 P3B nrlc132_1 161.888618564
Lrlc132 nrlc132_1 nrlc132_2 1.98043158535e-06
Crlc132 nrlc132_2 rlc2 3.54322531326e-11
* RLC[134] P3B-rlc4
Rrlc134 P3B nrlc134_1 307.59484454
Lrlc134 nrlc134_1 nrlc134_2 1.80823629906e-05
Crlc134 nrlc134_2 rlc4 1.76481525252e-11
* RLC[137] P3B-rlc7
Rrlc137 P3B nrlc137_1 4.26060435244
Lrlc137 nrlc137_1 nrlc137_2 1.11055377322e-07
Crlc137 nrlc137_2 rlc7 8.22721078443e-08
* RLC[138] P3B-rlc8
Rrlc138 P3B nrlc138_1 66.8553503476
Lrlc138 nrlc138_1 nrlc138_2 2.66262565908e-06
Crlc138 nrlc138_2 rlc8 7.399137482e-11
* RLC[139] P3B-rlc9
Rrlc139 P3B nrlc139_1 27.1592608325
Lrlc139 nrlc139_1 nrlc139_2 4.15696528118e-06
Crlc139 nrlc139_2 rlc9 1.53921191819e-05
* RLC[142] P3B-rlc12
Rrlc142 P3B nrlc142_1 786.260756369
Lrlc142 nrlc142_1 nrlc142_2 4.51044838859e-05
Crlc142 nrlc142_2 rlc12 4.52630523096e-12
* RLC[144] P3B-rlc14
Rrlc144 P3B nrlc144_1 78.2501703315
Lrlc144 nrlc144_1 nrlc144_2 2.58147558895e-06
Crlc144 nrlc144_2 rlc14 1.33171218608e-10
* RLC[145] P3B-rlc15
Rrlc145 P3B nrlc145_1 0.502296901288
Lrlc145 nrlc145_1 nrlc145_2 4.67069487074e-08
Crlc145 nrlc145_2 rlc15 0.001
* RLC[146] P3B-P1B
Rrlc146 P3B nrlc146_1 518.314528367
Lrlc146 nrlc146_1 nrlc146_2 2.49009302193e-05
Crlc146 nrlc146_2 P1B 4.10014714085e-12
* RLC[147] P4B-rlc0
Rrlc147 P4B nrlc147_1 22941.4143951
Lrlc147 nrlc147_1 nrlc147_2 1
Crlc147 nrlc147_2 rlc0 0.001
* RLC[148] P4B-rlc1
Rrlc148 P4B nrlc148_1 9.72815489293
Lrlc148 nrlc148_1 nrlc148_2 0.000147510540187
Crlc148 nrlc148_2 rlc1 0.000596451910962
* RLC[149] P4B-rlc2
Rrlc149 P4B nrlc149_1 338.174091645
Lrlc149 nrlc149_1 nrlc149_2 3.97704039201e-06
Crlc149 nrlc149_2 rlc2 2.42235331388e-11
* RLC[151] P4B-rlc4
Rrlc151 P4B nrlc151_1 172.95054488
Lrlc151 nrlc151_1 nrlc151_2 3.84654022088e-06
Crlc151 nrlc151_2 rlc4 3.26517885767e-10
* RLC[152] P4B-rlc5
Rrlc152 P4B nrlc152_1 187.557957326
Lrlc152 nrlc152_1 nrlc152_2 6.04515988169e-06
Crlc152 nrlc152_2 rlc5 3.40446205892e-10
* RLC[154] P4B-rlc7
Rrlc154 P4B nrlc154_1 0.414104461434
Lrlc154 nrlc154_1 nrlc154_2 1.97431640155e-07
Crlc154 nrlc154_2 rlc7 1.47716391074e-06
* RLC[156] P4B-rlc9
Rrlc156 P4B nrlc156_1 550.113518002
Lrlc156 nrlc156_1 nrlc156_2 9.33715266353e-06
Crlc156 nrlc156_2 rlc9 1.61628969518e-12
* RLC[157] P4B-rlc10
Rrlc157 P4B nrlc157_1 88.0366968467
Lrlc157 nrlc157_1 nrlc157_2 6.78365921086e-07
Crlc157 nrlc157_2 rlc10 1.25775991065e-09
* RLC[159] P4B-rlc12
Rrlc159 P4B nrlc159_1 1261.40006772
Lrlc159 nrlc159_1 nrlc159_2 5.41541823132e-05
Crlc159 nrlc159_2 rlc12 1.34272984515e-11
* RLC[160] P4B-rlc13
Rrlc160 P4B nrlc160_1 0.118776321794
Lrlc160 nrlc160_1 nrlc160_2 5.10923292342e-07
Crlc160 nrlc160_2 rlc13 5.77025346382e-06
* RLC[161] P4B-rlc14
Rrlc161 P4B nrlc161_1 1097.57269208
Lrlc161 nrlc161_1 nrlc161_2 1.71359816953e-05
Crlc161 nrlc161_2 rlc14 4.18247260175e-12
* RLC[162] P4B-rlc15
Rrlc162 P4B nrlc162_1 0.0244696741374
Lrlc162 nrlc162_1 nrlc162_2 9.50642038246e-08
Crlc162 nrlc162_2 rlc15 2.71972347429e-06
* RLC[164] rlc0-rlc1
Rrlc164 rlc0 nrlc164_1 0.107389999494
Lrlc164 nrlc164_1 nrlc164_2 1.09287746674e-08
Crlc164 nrlc164_2 rlc1 3.82930104332e-08
* RLC[165] rlc0-rlc2
Rrlc165 rlc0 nrlc165_1 0.588514489252
Lrlc165 nrlc165_1 nrlc165_2 1.20685792026e-07
Crlc165 nrlc165_2 rlc2 4.07236627239e-10
* RLC[167] rlc0-rlc4
Rrlc167 rlc0 nrlc167_1 2.88296246775
Lrlc167 nrlc167_1 nrlc167_2 7.76977293254e-07
Crlc167 nrlc167_2 rlc4 1.0386945787e-10
* RLC[170] rlc0-rlc7
Rrlc170 rlc0 nrlc170_1 54.5149287142
Lrlc170 nrlc170_1 nrlc170_2 4.5634325778e-07
Crlc170 nrlc170_2 rlc7 7.43336685848e-11
* RLC[171] rlc0-rlc8
Rrlc171 rlc0 nrlc171_1 12.4062607197
Lrlc171 nrlc171_1 nrlc171_2 5.27726511296e-06
Crlc171 nrlc171_2 rlc8 3.8096457669e-11
* RLC[174] rlc0-rlc11
Rrlc174 rlc0 nrlc174_1 34.9066246032
Lrlc174 nrlc174_1 nrlc174_2 1.95220268618e-06
Crlc174 nrlc174_2 rlc11 2.83713864547e-07
* RLC[176] rlc0-rlc13
Rrlc176 rlc0 nrlc176_1 16.8426752254
Lrlc176 nrlc176_1 nrlc176_2 5.6799629002e-06
Crlc176 nrlc176_2 rlc13 3.58992381325e-11
* RLC[177] rlc0-rlc14
Rrlc177 rlc0 nrlc177_1 43.7765271932
Lrlc177 nrlc177_1 nrlc177_2 1.68870789322e-05
Crlc177 nrlc177_2 rlc14 9.79105324111e-12
* RLC[178] rlc0-rlc15
Rrlc178 rlc0 nrlc178_1 5.58470552821
Lrlc178 nrlc178_1 nrlc178_2 1.82739475118e-06
Crlc178 nrlc178_2 rlc15 7.01104884042e-11
* RLC[179] rlc0-P1B
Rrlc179 rlc0 nrlc179_1 16.2247422665
Lrlc179 nrlc179_1 nrlc179_2 5.03024608583e-06
Crlc179 nrlc179_2 P1B 2.1232009949e-11
* RLC[183] rlc1-rlc5
Rrlc183 rlc1 nrlc183_1 1.55144860666
Lrlc183 nrlc183_1 nrlc183_2 3.5792963545e-07
Crlc183 nrlc183_2 rlc5 0.001
* RLC[184] rlc1-rlc6
Rrlc184 rlc1 nrlc184_1 1.65834698054
Lrlc184 nrlc184_1 nrlc184_2 1.49140748747e-08
Crlc184 nrlc184_2 rlc6 3.79911054672e-10
* RLC[188] rlc1-rlc10
Rrlc188 rlc1 nrlc188_1 43.4507176705
Lrlc188 nrlc188_1 nrlc188_2 2.84372669878e-06
Crlc188 nrlc188_2 rlc10 2.34109261515e-11
* RLC[189] rlc1-rlc11
Rrlc189 rlc1 nrlc189_1 0.0860066473668
Lrlc189 nrlc189_1 nrlc189_2 5.51113872655e-05
Crlc189 nrlc189_2 rlc11 0.000998564832499
* RLC[196] rlc2-rlc4
Rrlc196 rlc2 nrlc196_1 1.43455548363
Lrlc196 nrlc196_1 nrlc196_2 2.84438486602e-07
Crlc196 nrlc196_2 rlc4 2.31841707162e-10
* RLC[197] rlc2-rlc5
Rrlc197 rlc2 nrlc197_1 43.8861179612
Lrlc197 nrlc197_1 nrlc197_2 3.48520639172e-06
Crlc197 nrlc197_2 rlc5 3.92845075775e-11
* RLC[198] rlc2-rlc6
Rrlc198 rlc2 nrlc198_1 3.19828631254
Lrlc198 nrlc198_1 nrlc198_2 1.87829873808e-07
Crlc198 nrlc198_2 rlc6 2.99044753181e-10
* RLC[199] rlc2-rlc7
Rrlc199 rlc2 nrlc199_1 92.5171724282
Lrlc199 nrlc199_1 nrlc199_2 0.00428729075943
Crlc199 nrlc199_2 rlc7 0.000467296436883
* RLC[201] rlc2-rlc9
Rrlc201 rlc2 nrlc201_1 6.86085523084
Lrlc201 nrlc201_1 nrlc201_2 3.62731304192e-06
Crlc201 nrlc201_2 rlc9 8.56221279319e-11
* RLC[203] rlc2-rlc11
Rrlc203 rlc2 nrlc203_1 13.7899773019
Lrlc203 nrlc203_1 nrlc203_2 8.44534496237e-07
Crlc203 nrlc203_2 rlc11 3.03928576581e-11
* RLC[206] rlc2-rlc14
Rrlc206 rlc2 nrlc206_1 7.47384675252
Lrlc206 nrlc206_1 nrlc206_2 1.16666237029e-06
Crlc206 nrlc206_2 rlc14 2.60678857804e-11
* RLC[209] rlc3-rlc4
Rrlc209 rlc3 nrlc209_1 0.0771621763451
Lrlc209 nrlc209_1 nrlc209_2 0.000509257355807
Crlc209 nrlc209_2 rlc4 9.50355001446e-05
* RLC[211] rlc3-rlc6
Rrlc211 rlc3 nrlc211_1 24.4671357229
Lrlc211 nrlc211_1 nrlc211_2 1.32189329038e-06
Crlc211 nrlc211_2 rlc6 2.38288140151e-10
* RLC[212] rlc3-rlc7
Rrlc212 rlc3 nrlc212_1 277.941691972
Lrlc212 nrlc212_1 nrlc212_2 4.9447874548e-06
Crlc212 nrlc212_2 rlc7 1.19710066054e-11
* RLC[213] rlc3-rlc8
Rrlc213 rlc3 nrlc213_1 11.8045768345
Lrlc213 nrlc213_1 nrlc213_2 3.03126191412e-07
Crlc213 nrlc213_2 rlc8 3.09998706396e-08
* RLC[214] rlc3-rlc9
Rrlc214 rlc3 nrlc214_1 0.220702904879
Lrlc214 nrlc214_1 nrlc214_2 1.62625397542e-07
Crlc214 nrlc214_2 rlc9 2.51136627081e-07
* RLC[215] rlc3-rlc10
Rrlc215 rlc3 nrlc215_1 77.2023189281
Lrlc215 nrlc215_1 nrlc215_2 0.00401764744902
Crlc215 nrlc215_2 rlc10 2.52597221284e-05
* RLC[218] rlc3-rlc13
Rrlc218 rlc3 nrlc218_1 19.6474841969
Lrlc218 nrlc218_1 nrlc218_2 2.4084254527e-06
Crlc218 nrlc218_2 rlc13 2.68248815514e-10
* RLC[219] rlc3-rlc14
Rrlc219 rlc3 nrlc219_1 133.985880823
Lrlc219 nrlc219_1 nrlc219_2 4.75255672231e-05
Crlc219 nrlc219_2 rlc14 2.94148561043e-12
* RLC[223] rlc4-rlc6
Rrlc223 rlc4 nrlc223_1 32.4944411205
Lrlc223 nrlc223_1 nrlc223_2 1.08160644867e-05
Crlc223 nrlc223_2 rlc6 1.13817388018e-11
* RLC[226] rlc4-rlc9
Rrlc226 rlc4 nrlc226_1 0.0142591250469
Lrlc226 nrlc226_1 nrlc226_2 0.000135084123842
Crlc226 nrlc226_2 rlc9 0.00073820340761
* RLC[227] rlc4-rlc10
Rrlc227 rlc4 nrlc227_1 162.014660763
Lrlc227 nrlc227_1 nrlc227_2 1.38751761705e-05
Crlc227 nrlc227_2 rlc10 5.87337005918e-13
* RLC[228] rlc4-rlc11
Rrlc228 rlc4 nrlc228_1 42.1913903139
Lrlc228 nrlc228_1 nrlc228_2 1.02224481212e-05
Crlc228 nrlc228_2 rlc11 4.0925936807e-11
* RLC[229] rlc4-rlc12
Rrlc229 rlc4 nrlc229_1 0.895023733613
Lrlc229 nrlc229_1 nrlc229_2 1.78296761297e-07
Crlc229 nrlc229_2 rlc12 2.47308126744e-10
* RLC[231] rlc4-rlc14
Rrlc231 rlc4 nrlc231_1 14627.1519159
Lrlc231 nrlc231_1 nrlc231_2 1.00189144767e-06
Crlc231 nrlc231_2 rlc14 2.34832704363e-12
* RLC[238] rlc5-rlc10
Rrlc238 rlc5 nrlc238_1 73.8117231461
Lrlc238 nrlc238_1 nrlc238_2 2.67568741716e-06
Crlc238 nrlc238_2 rlc10 2.31926987805e-07
* RLC[239] rlc5-rlc11
Rrlc239 rlc5 nrlc239_1 2.6533632898
Lrlc239 nrlc239_1 nrlc239_2 3.0325592592e-07
Crlc239 nrlc239_2 rlc11 1.05508281022e-10
* RLC[240] rlc5-rlc12
Rrlc240 rlc5 nrlc240_1 44794735314.9
Lrlc240 nrlc240_1 nrlc240_2 6.81059885515e-06
Crlc240 nrlc240_2 rlc12 3.48495363009e-06
* RLC[241] rlc5-rlc13
Rrlc241 rlc5 nrlc241_1 41.9416340196
Lrlc241 nrlc241_1 nrlc241_2 1.23720653089e-06
Crlc241 nrlc241_2 rlc13 4.89836190981e-11
* RLC[242] rlc5-rlc14
Rrlc242 rlc5 nrlc242_1 14.4839960787
Lrlc242 nrlc242_1 nrlc242_2 3.74181795222e-06
Crlc242 nrlc242_2 rlc14 3.93812043516e-11
* RLC[243] rlc5-rlc15
Rrlc243 rlc5 nrlc243_1 44.8153630414
Lrlc243 nrlc243_1 nrlc243_2 1.86798273011e-05
Crlc243 nrlc243_2 rlc15 1.03341916053e-11
* RLC[244] rlc5-P1B
Rrlc244 rlc5 nrlc244_1 48.6668284176
Lrlc244 nrlc244_1 nrlc244_2 4.88580958522e-06
Crlc244 nrlc244_2 P1B 1.69620772211e-11
* RLC[245] rlc6-rlc7
Rrlc245 rlc6 nrlc245_1 181.205694783
Lrlc245 nrlc245_1 nrlc245_2 3.0740320937e-05
Crlc245 nrlc245_2 rlc7 4.10405417157e-12
* RLC[250] rlc6-rlc12
Rrlc250 rlc6 nrlc250_1 22.8125207588
Lrlc250 nrlc250_1 nrlc250_2 1.25747077093e-05
Crlc250 nrlc250_2 rlc12 2.68478081355e-11
* RLC[251] rlc6-rlc13
Rrlc251 rlc6 nrlc251_1 814.770650297
Lrlc251 nrlc251_1 nrlc251_2 0.150608969512
Crlc251 nrlc251_2 rlc13 3.14519583345e-07
* RLC[252] rlc6-rlc14
Rrlc252 rlc6 nrlc252_1 1517.11690472
Lrlc252 nrlc252_1 nrlc252_2 3.22896750753e-05
Crlc252 nrlc252_2 rlc14 8.52894961136e-11
* RLC[253] rlc6-rlc15
Rrlc253 rlc6 nrlc253_1 144.843515766
Lrlc253 nrlc253_1 nrlc253_2 6.88448715279e-05
Crlc253 nrlc253_2 rlc15 3.64612009054e-12
* RLC[254] rlc6-P1B
Rrlc254 rlc6 nrlc254_1 1190.96774673
Lrlc254 nrlc254_1 nrlc254_2 0.000364802939367
Crlc254 nrlc254_2 P1B 1.06055884076e-07
* RLC[255] rlc7-rlc8
Rrlc255 rlc7 nrlc255_1 115.412361563
Lrlc255 nrlc255_1 nrlc255_2 2.48856801086e-06
Crlc255 nrlc255_2 rlc8 1.454786221e-11
* RLC[257] rlc7-rlc10
Rrlc257 rlc7 nrlc257_1 36.0368110878
Lrlc257 nrlc257_1 nrlc257_2 7.50165260381e-06
Crlc257 nrlc257_2 rlc10 6.4183254195e-12
* RLC[258] rlc7-rlc11
Rrlc258 rlc7 nrlc258_1 0.810657097788
Lrlc258 nrlc258_1 nrlc258_2 5.8442397323e-09
Crlc258 nrlc258_2 rlc11 1.1651480898e-09
* RLC[259] rlc7-rlc12
Rrlc259 rlc7 nrlc259_1 135.084010746
Lrlc259 nrlc259_1 nrlc259_2 6.71258988407e-06
Crlc259 nrlc259_2 rlc12 1.02605894705e-10
* RLC[260] rlc7-rlc13
Rrlc260 rlc7 nrlc260_1 34.7164158588
Lrlc260 nrlc260_1 nrlc260_2 1.43936359355e-06
Crlc260 nrlc260_2 rlc13 4.3338405119e-11
* RLC[261] rlc7-rlc14
Rrlc261 rlc7 nrlc261_1 27757713244.3
Lrlc261 nrlc261_1 nrlc261_2 0.0239778667971
Crlc261 nrlc261_2 rlc14 0.001
* RLC[267] rlc8-rlc12
Rrlc267 rlc8 nrlc267_1 42.9390456073
Lrlc267 nrlc267_1 nrlc267_2 8.02289772681e-07
Crlc267 nrlc267_2 rlc12 1.01897617872e-10
* RLC[268] rlc8-rlc13
Rrlc268 rlc8 nrlc268_1 0.0116365604389
Lrlc268 nrlc268_1 nrlc268_2 5.99109539194e-07
Crlc268 nrlc268_2 rlc13 4.91602933912e-06
* RLC[273] rlc9-rlc11
Rrlc273 rlc9 nrlc273_1 11.4288764169
Lrlc273 nrlc273_1 nrlc273_2 5.15083701984e-07
Crlc273 nrlc273_2 rlc11 1.31859310255e-10
* RLC[275] rlc9-rlc13
Rrlc275 rlc9 nrlc275_1 3.91448967814
Lrlc275 nrlc275_1 nrlc275_2 2.61073202175e-07
Crlc275 nrlc275_2 rlc13 1.40977052586e-09
* RLC[276] rlc9-rlc14
Rrlc276 rlc9 nrlc276_1 14.0130260702
Lrlc276 nrlc276_1 nrlc276_2 1.73422697063e-06
Crlc276 nrlc276_2 rlc14 4.95907626394e-11
* RLC[279] rlc10-rlc11
Rrlc279 rlc10 nrlc279_1 24211.4232021
Lrlc279 nrlc279_1 nrlc279_2 0.0711556740571
Crlc279 nrlc279_2 rlc11 0.001
* RLC[280] rlc10-rlc12
Rrlc280 rlc10 nrlc280_1 48.3433646332
Lrlc280 nrlc280_1 nrlc280_2 1.35209379535e-05
Crlc280 nrlc280_2 rlc12 6.42822343309e-12
* RLC[281] rlc10-rlc13
Rrlc281 rlc10 nrlc281_1 0.974269009879
Lrlc281 nrlc281_1 nrlc281_2 2.62135699685e-11
Crlc281 nrlc281_2 rlc13 1.62453950723e-08
* RLC[283] rlc10-rlc15
Rrlc283 rlc10 nrlc283_1 51.2760865106
Lrlc283 nrlc283_1 nrlc283_2 2.9536931182e-05
Crlc283 nrlc283_2 rlc15 1.24822569541e-11
* RLC[284] rlc10-P1B
Rrlc284 rlc10 nrlc284_1 4613.71356422
Lrlc284 nrlc284_1 nrlc284_2 0.107814423161
Crlc284 nrlc284_2 P1B 0.001
* RLC[285] rlc11-rlc12
Rrlc285 rlc11 nrlc285_1 130.682848909
Lrlc285 nrlc285_1 nrlc285_2 3.8144423146e-06
Crlc285 nrlc285_2 rlc12 1.99662085739e-11
* RLC[286] rlc11-rlc13
Rrlc286 rlc11 nrlc286_1 0.0302864093065
Lrlc286 nrlc286_1 nrlc286_2 8.92681263727e-05
Crlc286 nrlc286_2 rlc13 0.001
* RLC[287] rlc11-rlc14
Rrlc287 rlc11 nrlc287_1 15.8854047922
Lrlc287 nrlc287_1 nrlc287_2 2.74227368809e-06
Crlc287 nrlc287_2 rlc14 1.20745711571e-11
* RLC[288] rlc11-rlc15
Rrlc288 rlc11 nrlc288_1 2.01559812169
Lrlc288 nrlc288_1 nrlc288_2 2.10530402578e-07
Crlc288 nrlc288_2 rlc15 3.83741427343e-10
* RLC[289] rlc11-P1B
Rrlc289 rlc11 nrlc289_1 30.0132595317
Lrlc289 nrlc289_1 nrlc289_2 3.49635613221e-07
Crlc289 nrlc289_2 P1B 1.39090374789e-07
* RLC[290] rlc12-rlc13
Rrlc290 rlc12 nrlc290_1 20.1870310377
Lrlc290 nrlc290_1 nrlc290_2 1.48115191747e-06
Crlc290 nrlc290_2 rlc13 5.88505387207e-11
* RLC[293] rlc12-P1B
Rrlc293 rlc12 nrlc293_1 2.64346835886
Lrlc293 nrlc293_1 nrlc293_2 3.30414579427e-07
Crlc293 nrlc293_2 P1B 4.01748353029e-10
* RLC[296] rlc13-P1B
Rrlc296 rlc13 nrlc296_1 0.106778396023
Lrlc296 nrlc296_1 nrlc296_2 9.47688536299e-10
Crlc296 nrlc296_2 P1B 1.99299199834e-07
* RLC[297] rlc14-rlc15
Rrlc297 rlc14 nrlc297_1 0.726374226056
Lrlc297 nrlc297_1 nrlc297_2 2.34795224602e-07
Crlc297 nrlc297_2 rlc15 4.94454004907e-10
* RLC[298] rlc14-P1B
Rrlc298 rlc14 nrlc298_1 86.2052959316
Lrlc298 nrlc298_1 nrlc298_2 3.31080904799e-05
Crlc298 nrlc298_2 P1B 4.95021121576e-12
* DC[0] P1A-P2A
Rdc0 P1A ndc0_1 0.0544254811357
Ldc0 ndc0_1 P2A 8.95152380051e-08
* DC[23] P3A-P4A
Rdc23 P3A ndc23_1 0.0102357853056
Ldc23 ndc23_1 P4A 9.59056842537e-08
* DC[42] P1B-P2B
Rdc42 P1B ndc42_1 0.0987246386976
Ldc42 ndc42_1 P2B 1.02056146456e-07
* DC[43] P1B-P3B
Rdc43 P1B ndc43_1 566.010389521
Ldc43 ndc43_1 P3B 0.00664937527848
* DC[44] P1B-P4B
Rdc44 P1B ndc44_1 8457.33239059
Ldc44 ndc44_1 P4B 1
* DC[47] P1B-dc2
Rdc47 P1B ndc47_1 0.527792472432
Ldc47 ndc47_1 dc2 8.43925900254e-08
* DC[48] P1B-dc3
Rdc48 P1B ndc48_1 0.0199013833782
Ldc48 ndc48_1 dc3 3.65222074013e-09
* DC[51] P2B-P4B
Rdc51 P2B ndc51_1 138.984780657
Ldc51 ndc51_1 P4B 0.000557281955099
* DC[52] P2B-dc0
Rdc52 P2B ndc52_1 0.259921250418
Ldc52 ndc52_1 dc0 1.63300267314e-05
* DC[54] P2B-dc2
Rdc54 P2B ndc54_1 0.0100163724641
Ldc54 ndc54_1 dc2 6.37899304812e-05
* DC[55] P2B-dc3
Rdc55 P2B ndc55_1 0.0812251949091
Ldc55 ndc55_1 dc3 2.08342533955e-08
* DC[56] P2B-P1B
Rdc56 P2B ndc56_1 0.106156637109
Ldc56 ndc56_1 P1B 4.48224297058e-07
* DC[57] P3B-P4B
Rdc57 P3B ndc57_1 0.137040523413
Ldc57 ndc57_1 P4B 1.37415783307e-07
* DC[58] P3B-dc0
Rdc58 P3B ndc58_1 0.0101298133846
Ldc58 ndc58_1 dc0 0.000338603555078
* DC[59] P3B-dc1
Rdc59 P3B ndc59_1 0.0832413432193
Ldc59 ndc59_1 dc1 9.01977787273e-07
* DC[62] P3B-P1B
Rdc62 P3B ndc62_1 1019.80050816
Ldc62 ndc62_1 P1B 0.0119882600117
* DC[63] P4B-dc0
Rdc63 P4B ndc63_1 0.940692742942
Ldc63 ndc63_1 dc0 1.20850613587e-06
* DC[66] P4B-dc3
Rdc66 P4B ndc66_1 17989.9267781
Ldc66 ndc66_1 dc3 1
* DC[67] P4B-P1B
Rdc67 P4B ndc67_1 32146.0537205
Ldc67 ndc67_1 P1B 1
* DC[68] dc0-dc1
Rdc68 dc0 ndc68_1 0.01
Ldc68 ndc68_1 dc1 9.95050259446e-06
* DC[72] dc1-dc2
Rdc72 dc1 ndc72_1 0.0714149678425
Ldc72 ndc72_1 dc2 1.13893060648e-08
* DC[76] dc2-P1B
Rdc76 dc2 ndc76_1 2.10634123497
Ldc76 ndc76_1 P1B 3.36798253524e-07
* ---- leaks
Rleak_P1A P1A P1B 1e+12
Rleak_P2A P2A P1B 1e+12
Rleak_P2B P2B P1B 1e+12
Rleak_P3A P3A P1B 1e+12
Rleak_P3B P3B P1B 1e+12
Rleak_P4A P4A P1B 1e+12
Rleak_P4B P4B P1B 1e+12
Rleak_dc0 dc0 P1B 1e+12
Rleak_dc1 dc1 P1B 1e+12
Rleak_dc2 dc2 P1B 1e+12
Rleak_dc3 dc3 P1B 1e+12
Rleak_rlc0 rlc0 P1B 1e+12
Rleak_rlc1 rlc1 P1B 1e+12
Rleak_rlc10 rlc10 P1B 1e+12
Rleak_rlc11 rlc11 P1B 1e+12
Rleak_rlc12 rlc12 P1B 1e+12
Rleak_rlc13 rlc13 P1B 1e+12
Rleak_rlc14 rlc14 P1B 1e+12
Rleak_rlc15 rlc15 P1B 1e+12
Rleak_rlc2 rlc2 P1B 1e+12
Rleak_rlc3 rlc3 P1B 1e+12
Rleak_rlc4 rlc4 P1B 1e+12
Rleak_rlc5 rlc5 P1B 1e+12
Rleak_rlc6 rlc6 P1B 1e+12
Rleak_rlc7 rlc7 P1B 1e+12
Rleak_rlc8 rlc8 P1B 1e+12
Rleak_rlc9 rlc9 P1B 1e+12
.ends fitted
