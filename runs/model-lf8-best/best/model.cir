* fitted: 8-port fitted model, reference z0 = 50 Ohm
* every pin is a port against GND
.subckt fitted P1A P1B P2A P2B P3A P3B P4A P4B GND
* ---- branches
* RLC[1] P1A-P3A
Rrlc1 P1A nrlc1_1 10043.0145885
Lrlc1 nrlc1_1 nrlc1_2 3.68714554969e-12
Crlc1 nrlc1_2 P3A 1.59107405296e-13
* RLC[2] P1A-P4A
Rrlc2 P1A nrlc2_1 31697.8280791
Lrlc2 nrlc2_1 nrlc2_2 0.0654785893026
Crlc2 nrlc2_2 P4A 1.63540894838e-13
* RLC[3] P1A-P1B
Rrlc3 P1A nrlc3_1 1.18810037807e+12
Lrlc3 nrlc3_1 nrlc3_2 0.00818092843739
Crlc3 nrlc3_2 P1B 3.19272064867e-09
* RLC[4] P1A-P2B
Rrlc4 P1A nrlc4_1 6095.26024846
Lrlc4 nrlc4_1 nrlc4_2 3.76227153918e-05
Crlc4 nrlc4_2 P2B 1.23495996956e-12
* RLC[5] P1A-P3B
Rrlc5 P1A nrlc5_1 1.59643728269e+12
Lrlc5 nrlc5_1 nrlc5_2 0.999997108771
Crlc5 nrlc5_2 P3B 1.37716395644e-05
* RLC[6] P1A-P4B
Rrlc6 P1A nrlc6_1 5.69931076562
Lrlc6 nrlc6_1 nrlc6_2 3.06716722884e-07
Crlc6 nrlc6_2 P4B 1.04918064251e-11
* RLC[15] P1A-rlc8
Rrlc15 P1A nrlc15_1 422832.537935
Lrlc15 nrlc15_1 nrlc15_2 1
Crlc15 nrlc15_2 rlc8 6.21470746776e-15
* RLC[22] P1A-rlc15
Rrlc22 P1A nrlc22_1 271126.396984
Lrlc22 nrlc22_1 nrlc22_2 1
Crlc22 nrlc22_2 rlc15 1.511519955e-14
* RLC[24] P2A-P3A
Rrlc24 P2A nrlc24_1 1e+15
Lrlc24 nrlc24_1 nrlc24_2 0.421334412464
Crlc24 nrlc24_2 P3A 1.13806563637e-08
* RLC[25] P2A-P4A
Rrlc25 P2A nrlc25_1 1e+15
Lrlc25 nrlc25_1 nrlc25_2 0.36868688577
Crlc25 nrlc25_2 P4A 0.000524487477675
* RLC[26] P2A-P1B
Rrlc26 P2A nrlc26_1 212529648480
Lrlc26 nrlc26_1 nrlc26_2 0.996992938442
Crlc26 nrlc26_2 P1B 1.14263935796e-05
* RLC[27] P2A-P2B
Rrlc27 P2A nrlc27_1 30002260.7667
Lrlc27 nrlc27_1 nrlc27_2 2.96766201574e-05
Crlc27 nrlc27_2 P2B 9.96661836488e-14
* RLC[28] P2A-P3B
Rrlc28 P2A nrlc28_1 250888.419673
Lrlc28 nrlc28_1 nrlc28_2 1
Crlc28 nrlc28_2 P3B 1.76520951074e-14
* RLC[29] P2A-P4B
Rrlc29 P2A nrlc29_1 366502054941
Lrlc29 nrlc29_1 nrlc29_2 0.996974528388
Crlc29 nrlc29_2 P4B 3.06246194412e-08
* RLC[34] P2A-rlc4
Rrlc34 P2A nrlc34_1 98076.7037942
Lrlc34 nrlc34_1 nrlc34_2 0.0407854746782
Crlc34 nrlc34_2 rlc4 4.71119726099e-15
* RLC[41] P2A-rlc11
Rrlc41 P2A nrlc41_1 16140625.3132
Lrlc41 nrlc41_1 nrlc41_2 1
Crlc41 nrlc41_2 rlc11 4.2649778364e-18
* RLC[47] P3A-P4A
Rrlc47 P3A nrlc47_1 30.6845836984
Lrlc47 nrlc47_1 nrlc47_2 0.00292727891985
Crlc47 nrlc47_2 P4A 0.001
* RLC[48] P3A-P1B
Rrlc48 P3A nrlc48_1 1599.35357107
Lrlc48 nrlc48_1 nrlc48_2 1.11215241878e-05
Crlc48 nrlc48_2 P1B 3.7749600016e-12
* RLC[49] P3A-P2B
Rrlc49 P3A nrlc49_1 8937.0286866
Lrlc49 nrlc49_1 nrlc49_2 0.000467711621237
Crlc49 nrlc49_2 P2B 1.01502859317e-12
* RLC[50] P3A-P3B
Rrlc50 P3A nrlc50_1 88964571398.8
Lrlc50 nrlc50_1 nrlc50_2 0.161968786409
Crlc50 nrlc50_2 P3B 2.44384695551e-12
* RLC[51] P3A-P4B
Rrlc51 P3A nrlc51_1 4.6619668101
Lrlc51 nrlc51_1 nrlc51_2 2.49178762816e-07
Crlc51 nrlc51_2 P4B 1.27388481606e-11
* RLC[52] P3A-rlc0
Rrlc52 P3A nrlc52_1 1433.63800624
Lrlc52 nrlc52_1 nrlc52_2 1.8908192133e-05
Crlc52 nrlc52_2 rlc0 1.02218260413e-14
* RLC[53] P3A-rlc1
Rrlc53 P3A nrlc53_1 356131.815996
Lrlc53 nrlc53_1 nrlc53_2 6.47177226022e-09
Crlc53 nrlc53_2 rlc1 1.01819507537e-16
* RLC[57] P3A-rlc5
Rrlc57 P3A nrlc57_1 194458.998913
Lrlc57 nrlc57_1 nrlc57_2 1
Crlc57 nrlc57_2 rlc5 2.93833561578e-14
* RLC[58] P3A-rlc6
Rrlc58 P3A nrlc58_1 559261.843287
Lrlc58 nrlc58_1 nrlc58_2 1
Crlc58 nrlc58_2 rlc6 3.59542397845e-15
* RLC[62] P3A-rlc10
Rrlc62 P3A nrlc62_1 5290.35420037
Lrlc62 nrlc62_1 nrlc62_2 0.000268980996501
Crlc62 nrlc62_2 rlc10 1.06784836952e-14
* RLC[65] P3A-rlc13
Rrlc65 P3A nrlc65_1 245078.873385
Lrlc65 nrlc65_1 nrlc65_2 1
Crlc65 nrlc65_2 rlc13 1.84988929876e-14
* RLC[67] P3A-rlc15
Rrlc67 P3A nrlc67_1 29282.1285331
Lrlc67 nrlc67_1 nrlc67_2 2.27589953515e-12
Crlc67 nrlc67_2 rlc15 2.12836973968e-15
* RLC[69] P4A-P1B
Rrlc69 P4A nrlc69_1 1.37847508074e+12
Lrlc69 nrlc69_1 nrlc69_2 0.733562854879
Crlc69 nrlc69_2 P1B 1.97025341806e-05
* RLC[70] P4A-P2B
Rrlc70 P4A nrlc70_1 583844722684
Lrlc70 nrlc70_1 nrlc70_2 0.992061083636
Crlc70 nrlc70_2 P2B 9.38199417676e-10
* RLC[71] P4A-P3B
Rrlc71 P4A nrlc71_1 89374629618.8
Lrlc71 nrlc71_1 nrlc71_2 0.999786359768
Crlc71 nrlc71_2 P3B 9.52445227435e-07
* RLC[72] P4A-P4B
Rrlc72 P4A nrlc72_1 102524.788118
Lrlc72 nrlc72_1 nrlc72_2 1
Crlc72 nrlc72_2 P4B 1.05706022056e-13
* RLC[78] P4A-rlc5
Rrlc78 P4A nrlc78_1 425818.280587
Lrlc78 nrlc78_1 nrlc78_2 1
Crlc78 nrlc78_2 rlc5 6.12786073324e-15
* RLC[79] P4A-rlc6
Rrlc79 P4A nrlc79_1 29944439375.4
Lrlc79 nrlc79_1 nrlc79_2 0.976327560861
Crlc79 nrlc79_2 rlc6 7.77901109298e-16
* RLC[80] P4A-rlc7
Rrlc80 P4A nrlc80_1 125556.699745
Lrlc80 nrlc80_1 nrlc80_2 1
Crlc80 nrlc80_2 rlc7 7.04819168923e-14
* RLC[88] P4A-rlc15
Rrlc88 P4A nrlc88_1 481281.759845
Lrlc88 nrlc88_1 nrlc88_2 0.0226626610797
Crlc88 nrlc88_2 rlc15 1.08710023417e-16
* RLC[91] P1B-P3B
Rrlc91 P1B nrlc91_1 138490.941681
Lrlc91 nrlc91_1 nrlc91_2 1
Crlc91 nrlc91_2 P3B 5.79314973701e-14
* RLC[95] P1B-rlc2
Rrlc95 P1B nrlc95_1 341946.611994
Lrlc95 nrlc95_1 nrlc95_2 0.0129489291016
Crlc95 nrlc95_2 rlc2 1.2304804936e-16
* RLC[96] P1B-rlc3
Rrlc96 P1B nrlc96_1 153513.244192
Lrlc96 nrlc96_1 nrlc96_2 1
Crlc96 nrlc96_2 rlc3 4.71482731709e-14
* RLC[98] P1B-rlc5
Rrlc98 P1B nrlc98_1 304992.249901
Lrlc98 nrlc98_1 nrlc98_2 1
Crlc98 nrlc98_2 rlc5 1.19448275226e-14
* RLC[99] P1B-rlc6
Rrlc99 P1B nrlc99_1 158453.078632
Lrlc99 nrlc99_1 nrlc99_2 0.000924793926098
Crlc99 nrlc99_2 rlc6 4.09261692533e-17
* RLC[100] P1B-rlc7
Rrlc100 P1B nrlc100_1 673282.351961
Lrlc100 nrlc100_1 nrlc100_2 1
Crlc100 nrlc100_2 rlc7 2.4511112808e-15
* RLC[108] P1B-rlc15
Rrlc108 P1B nrlc108_1 158609.955379
Lrlc108 nrlc108_1 nrlc108_2 0.00754020653896
Crlc108 nrlc108_2 rlc15 3.33027307967e-16
* RLC[111] P2B-P4B
Rrlc111 P2B nrlc111_1 0.00718604280278
Lrlc111 nrlc111_1 nrlc111_2 1.10644692231e-07
Crlc111 nrlc111_2 P4B 0.001
* RLC[115] P2B-rlc3
Rrlc115 P2B nrlc115_1 342918.698951
Lrlc115 nrlc115_1 nrlc115_2 1
Crlc115 nrlc115_2 rlc3 9.44876735221e-15
* RLC[117] P2B-rlc5
Rrlc117 P2B nrlc117_1 338.961622288
Lrlc117 nrlc117_1 nrlc117_2 1.6628018572e-12
Crlc117 nrlc117_2 rlc5 2.18093706153e-17
* RLC[125] P2B-rlc13
Rrlc125 P2B nrlc125_1 342918.019888
Lrlc125 nrlc125_1 nrlc125_2 1
Crlc125 nrlc125_2 rlc13 9.44880477403e-15
* RLC[127] P2B-rlc15
Rrlc127 P2B nrlc127_1 44495.77565
Lrlc127 nrlc127_1 nrlc127_2 0.00684227985491
Crlc127 nrlc127_2 rlc15 3.83990747768e-15
* RLC[131] P3B-rlc1
Rrlc131 P3B nrlc131_1 9.72819113323
Lrlc131 nrlc131_1 nrlc131_2 3.09967076741e-09
Crlc131 nrlc131_2 rlc1 3.63922467611e-14
* RLC[132] P3B-rlc2
Rrlc132 P3B nrlc132_1 116653.149561
Lrlc132 nrlc132_1 nrlc132_2 1
Crlc132 nrlc132_2 rlc2 8.16515724155e-14
* RLC[135] P3B-rlc5
Rrlc135 P3B nrlc135_1 304992.249576
Lrlc135 nrlc135_1 nrlc135_2 1
Crlc135 nrlc135_2 rlc5 1.1944827548e-14
* RLC[136] P3B-rlc6
Rrlc136 P3B nrlc136_1 285641.756665
Lrlc136 nrlc136_1 nrlc136_2 1
Crlc136 nrlc136_2 rlc6 1.361802415e-14
* RLC[138] P3B-rlc8
Rrlc138 P3B nrlc138_1 5512737.51658
Lrlc138 nrlc138_1 nrlc138_2 1
Crlc138 nrlc138_2 rlc8 3.65614037317e-17
* RLC[142] P3B-rlc12
Rrlc142 P3B nrlc142_1 342926.947324
Lrlc142 nrlc142_1 nrlc142_2 1
Crlc142 nrlc142_2 rlc12 9.44831281794e-15
* RLC[144] P3B-rlc14
Rrlc144 P3B nrlc144_1 216127.62352
Lrlc144 nrlc144_1 nrlc144_2 1
Crlc144 nrlc144_2 rlc14 2.37868500235e-14
* RLC[153] P4B-rlc6
Rrlc153 P4B nrlc153_1 157822.359546
Lrlc153 nrlc153_1 nrlc153_2 1
Crlc153 nrlc153_2 rlc6 4.46087882654e-14
* RLC[160] P4B-rlc13
Rrlc160 P4B nrlc160_1 0.00981075855939
Lrlc160 nrlc160_1 nrlc160_2 4.46226551496e-13
Crlc160 nrlc160_2 rlc13 5.15119182533e-12
* RLC[161] P4B-rlc14
Rrlc161 P4B nrlc161_1 137187.040576
Lrlc161 nrlc161_1 nrlc161_2 1
Crlc161 nrlc161_2 rlc14 5.90379563395e-14
* RLC[165] rlc0-rlc2
Rrlc165 rlc0 nrlc165_1 182.018487843
Lrlc165 nrlc165_1 nrlc165_2 1
Crlc165 nrlc165_2 rlc2 3.35371757249e-08
* RLC[166] rlc0-rlc3
Rrlc166 rlc0 nrlc166_1 23.1696774902
Lrlc166 nrlc166_1 nrlc166_2 0.0118021583181
Crlc166 nrlc166_2 rlc3 2.44274959142e-08
* RLC[180] rlc1-rlc2
Rrlc180 rlc1 nrlc180_1 8.12694417229
Lrlc180 nrlc180_1 nrlc180_2 1
Crlc180 nrlc180_2 rlc2 1.68229803547e-05
* RLC[182] rlc1-rlc4
Rrlc182 rlc1 nrlc182_1 528.319665464
Lrlc182 nrlc182_1 nrlc182_2 0.393675407983
Crlc182 nrlc182_2 rlc4 1.61239613738e-09
* RLC[187] rlc1-rlc9
Rrlc187 rlc1 nrlc187_1 0.0361784519664
Lrlc187 nrlc187_1 nrlc187_2 8.86756542558e-05
Crlc187 nrlc187_2 rlc9 0.000795522148833
* RLC[195] rlc2-rlc3
Rrlc195 rlc2 nrlc195_1 1.08636513157
Lrlc195 nrlc195_1 nrlc195_2 1
Crlc195 nrlc195_2 rlc3 0.000941468632296
* RLC[196] rlc2-rlc4
Rrlc196 rlc2 nrlc196_1 19.7118227314
Lrlc196 nrlc196_1 nrlc196_2 1
Crlc196 nrlc196_2 rlc4 2.86294391429e-06
* RLC[197] rlc2-rlc5
Rrlc197 rlc2 nrlc197_1 96398.9351933
Lrlc197 nrlc197_1 nrlc197_2 1
Crlc197 nrlc197_2 rlc5 1.19567463709e-13
* RLC[198] rlc2-rlc6
Rrlc198 rlc2 nrlc198_1 2.53702347706
Lrlc198 nrlc198_1 nrlc198_2 1
Crlc198 nrlc198_2 rlc6 0.000172626918569
* RLC[199] rlc2-rlc7
Rrlc199 rlc2 nrlc199_1 3.6262569911
Lrlc199 nrlc199_1 nrlc199_2 1
Crlc199 nrlc199_2 rlc7 8.44968136954e-05
* RLC[200] rlc2-rlc8
Rrlc200 rlc2 nrlc200_1 1.622426978
Lrlc200 nrlc200_1 nrlc200_2 1
Crlc200 nrlc200_2 rlc8 0.000422173829243
* RLC[201] rlc2-rlc9
Rrlc201 rlc2 nrlc201_1 179.576121321
Lrlc201 nrlc201_1 nrlc201_2 1
Crlc201 nrlc201_2 rlc9 3.44556396396e-08
* RLC[203] rlc2-rlc11
Rrlc203 rlc2 nrlc203_1 232.913060344
Lrlc203 nrlc203_1 nrlc203_2 1
Crlc203 nrlc203_2 rlc11 2.04818795096e-08
* RLC[204] rlc2-rlc12
Rrlc204 rlc2 nrlc204_1 1254522.44649
Lrlc204 nrlc204_1 nrlc204_2 0.0462252421258
Crlc204 nrlc204_2 rlc12 3.26347141163e-17
* RLC[205] rlc2-rlc13
Rrlc205 rlc2 nrlc205_1 1.05432191497
Lrlc205 nrlc205_1 nrlc205_2 1
Crlc205 nrlc205_2 rlc13 0.00099956495899
* RLC[206] rlc2-rlc14
Rrlc206 rlc2 nrlc206_1 136.389054381
Lrlc206 nrlc206_1 nrlc206_2 1
Crlc206 nrlc206_2 rlc14 5.97308168402e-08
* RLC[207] rlc2-rlc15
Rrlc207 rlc2 nrlc207_1 1.13541703079
Lrlc207 nrlc207_1 nrlc207_2 1
Crlc207 nrlc207_2 rlc15 0.000861879760296
* RLC[208] rlc2-GND
Rrlc208 rlc2 nrlc208_1 8.72104018757
Lrlc208 nrlc208_1 nrlc208_2 1
Crlc208 nrlc208_2 GND 1.46091692323e-05
* RLC[215] rlc3-rlc10
Rrlc215 rlc3 nrlc215_1 0.376467578921
Lrlc215 nrlc215_1 nrlc215_2 2.81020990028e-09
Crlc215 nrlc215_2 rlc10 2.20313488817e-11
* RLC[218] rlc3-rlc13
Rrlc218 rlc3 nrlc218_1 0.00213610153334
Lrlc218 nrlc218_1 nrlc218_2 4.10663678466e-06
Crlc218 nrlc218_2 rlc13 0.001
* RLC[219] rlc3-rlc14
Rrlc219 rlc3 nrlc219_1 27.9969831656
Lrlc219 nrlc219_1 nrlc219_2 7.39302691064e-07
Crlc219 nrlc219_2 rlc14 1.38622886427e-12
* RLC[220] rlc3-rlc15
Rrlc220 rlc3 nrlc220_1 0.0367960010376
Lrlc220 nrlc220_1 nrlc220_2 0.00106674938676
Crlc220 nrlc220_2 rlc15 0.00087542440076
* RLC[221] rlc3-GND
Rrlc221 rlc3 nrlc221_1 0.0318884722869
Lrlc221 nrlc221_1 nrlc221_2 3.43033743877e-06
Crlc221 nrlc221_2 GND 3.74823582004e-06
* RLC[226] rlc4-rlc9
Rrlc226 rlc4 nrlc226_1 0.234564554875
Lrlc226 nrlc226_1 nrlc226_2 1.11029481108e-07
Crlc226 nrlc226_2 rlc9 2.2421828582e-09
* RLC[231] rlc4-rlc14
Rrlc231 rlc4 nrlc231_1 0.143475537632
Lrlc231 nrlc231_1 nrlc231_2 5.93915263995e-08
Crlc231 nrlc231_2 rlc14 3.20572494028e-09
* RLC[235] rlc5-rlc7
Rrlc235 rlc5 nrlc235_1 0.171455291874
Lrlc235 nrlc235_1 nrlc235_2 7.45444716457e-12
Crlc235 nrlc235_2 rlc7 2.81754683334e-13
* RLC[237] rlc5-rlc9
Rrlc237 rlc5 nrlc237_1 380.647163696
Lrlc237 nrlc237_1 nrlc237_2 1
Crlc237 nrlc237_2 rlc9 7.66853306273e-09
* RLC[241] rlc5-rlc13
Rrlc241 rlc5 nrlc241_1 366.978566845
Lrlc241 nrlc241_1 nrlc241_2 1
Crlc241 nrlc241_2 rlc13 8.25042061646e-09
* RLC[242] rlc5-rlc14
Rrlc242 rlc5 nrlc242_1 61.1903846712
Lrlc242 nrlc242_1 nrlc242_2 8.65860205868e-05
Crlc242 nrlc242_2 rlc14 2.5694425048e-11
* RLC[253] rlc6-rlc15
Rrlc253 rlc6 nrlc253_1 10456.608255
Lrlc253 nrlc253_1 nrlc253_2 1
Crlc253 nrlc253_2 rlc15 1.01619210066e-11
* RLC[256] rlc7-rlc9
Rrlc256 rlc7 nrlc256_1 1707.0184987
Lrlc256 nrlc256_1 nrlc256_2 0.000419377263048
Crlc256 nrlc256_2 rlc9 1.59913790103e-13
* RLC[257] rlc7-rlc10
Rrlc257 rlc7 nrlc257_1 0.0927799840977
Lrlc257 nrlc257_1 nrlc257_2 0.00701571329917
Crlc257 nrlc257_2 rlc10 0.000905567309062
* RLC[260] rlc7-rlc13
Rrlc260 rlc7 nrlc260_1 0.0384276402094
Lrlc260 nrlc260_1 nrlc260_2 3.28023853622e-12
Crlc260 nrlc260_2 rlc13 2.46817236433e-12
* RLC[268] rlc8-rlc13
Rrlc268 rlc8 nrlc268_1 40899.5271272
Lrlc268 nrlc268_1 nrlc268_2 0.000633605574561
Crlc268 nrlc268_2 rlc13 4.20862185921e-16
* RLC[271] rlc8-GND
Rrlc271 rlc8 nrlc271_1 1.63445537246
Lrlc271 nrlc271_1 nrlc271_2 1
Crlc271 nrlc271_2 GND 0.000415983201596
* RLC[275] rlc9-rlc13
Rrlc275 rlc9 nrlc275_1 0.03176684642
Lrlc275 nrlc275_1 nrlc275_2 1.05073930025e-05
Crlc275 nrlc275_2 rlc13 1.15692248042e-05
* RLC[282] rlc10-rlc14
Rrlc282 rlc10 nrlc282_1 3.07148096013
Lrlc282 nrlc282_1 nrlc282_2 5.41216963929e-08
Crlc282 nrlc282_2 rlc14 7.35538472443e-12
* RLC[283] rlc10-rlc15
Rrlc283 rlc10 nrlc283_1 0.083989175136
Lrlc283 nrlc283_1 nrlc283_2 2.04690628272e-12
Crlc283 nrlc283_2 rlc15 3.22410233026e-13
* RLC[284] rlc10-GND
Rrlc284 rlc10 nrlc284_1 0.00299319834465
Lrlc284 nrlc284_1 nrlc284_2 6.61845427612e-10
Crlc284 nrlc284_2 GND 8.20810816161e-08
* RLC[286] rlc11-rlc13
Rrlc286 rlc11 nrlc286_1 2.24066612325
Lrlc286 nrlc286_1 nrlc286_2 1
Crlc286 nrlc286_2 rlc13 0.000221311098774
* RLC[290] rlc12-rlc13
Rrlc290 rlc12 nrlc290_1 0.212048205086
Lrlc290 nrlc290_1 nrlc290_2 3.38472245573e-05
Crlc290 nrlc290_2 rlc13 8.36394853695e-07
* RLC[292] rlc12-rlc15
Rrlc292 rlc12 nrlc292_1 0.00303975450971
Lrlc292 nrlc292_1 nrlc292_2 1.39636561942e-12
Crlc292 nrlc292_2 rlc15 1.67911180511e-10
* RLC[294] rlc13-rlc14
Rrlc294 rlc13 nrlc294_1 1.31684021782
Lrlc294 nrlc294_1 nrlc294_2 1.20679204221e-05
Crlc294 nrlc294_2 rlc14 7.73256829454e-09
* RLC[296] rlc13-GND
Rrlc296 rlc13 nrlc296_1 0.0148660589716
Lrlc296 nrlc296_1 nrlc296_2 8.30030238389e-07
Crlc296 nrlc296_2 GND 4.17310874821e-06
* RLC[299] rlc15-GND
Rrlc299 rlc15 nrlc299_1 237.28127723
Lrlc299 nrlc299_1 nrlc299_2 0.000745408123047
Crlc299 nrlc299_2 GND 1.47104063287e-11
* DC[0] P1A-P2A
Rdc0 P1A ndc0_1 0.0859086528865
Ldc0 ndc0_1 P2A 1.05963838693e-07
* DC[3] P1A-P1B
Rdc3 P1A ndc3_1 2.23358880643e+12
Ldc3 ndc3_1 P1B 1
* DC[5] P1A-P3B
Rdc5 P1A ndc5_1 2.23351564465e+12
Ldc5 ndc5_1 P3B 1
* DC[7] P1A-dc0
Rdc7 P1A ndc7_1 2.23355200449e+12
Ldc7 ndc7_1 dc0 1
* DC[8] P1A-dc1
Rdc8 P1A ndc8_1 2.23354224093e+12
Ldc8 ndc8_1 dc1 1
* DC[10] P1A-dc3
Rdc10 P1A ndc10_1 2.23353428431e+12
Ldc10 ndc10_1 dc3 1
* DC[12] P2A-P3A
Rdc12 P2A ndc12_1 1e+15
Ldc12 ndc12_1 P3A 1
* DC[13] P2A-P4A
Rdc13 P2A ndc13_1 1e+15
Ldc13 ndc13_1 P4A 1
* DC[14] P2A-P1B
Rdc14 P2A ndc14_1 2.23352913661e+12
Ldc14 ndc14_1 P1B 1
* DC[15] P2A-P2B
Rdc15 P2A ndc15_1 2.23355115496e+12
Ldc15 ndc15_1 P2B 1
* DC[16] P2A-P3B
Rdc16 P2A ndc16_1 2.23354604401e+12
Ldc16 ndc16_1 P3B 1
* DC[17] P2A-P4B
Rdc17 P2A ndc17_1 2.23353897302e+12
Ldc17 ndc17_1 P4B 1
* DC[18] P2A-dc0
Rdc18 P2A ndc18_1 2.23354246697e+12
Ldc18 ndc18_1 dc0 1
* DC[19] P2A-dc1
Rdc19 P2A ndc19_1 2.23353232568e+12
Ldc19 ndc19_1 dc1 1
* DC[20] P2A-dc2
Rdc20 P2A ndc20_1 2.23354003836e+12
Ldc20 ndc20_1 dc2 1
* DC[21] P2A-dc3
Rdc21 P2A ndc21_1 2.23354169238e+12
Ldc21 ndc21_1 dc3 1
* DC[23] P3A-P4A
Rdc23 P3A ndc23_1 0.130433805569
Ldc23 ndc23_1 P4A 1.57165520195e-07
* DC[26] P3A-P3B
Rdc26 P3A ndc26_1 7.45130053098e+13
Ldc26 ndc26_1 P3B 1
* DC[28] P3A-dc0
Rdc28 P3A ndc28_1 1.01883566292e+13
Ldc28 ndc28_1 dc0 1
* DC[31] P3A-dc3
Rdc31 P3A ndc31_1 5.1222272756e+13
Ldc31 ndc31_1 dc3 1
* DC[33] P4A-P1B
Rdc33 P4A ndc33_1 1.33507905879e+13
Ldc33 ndc33_1 P1B 1
* DC[37] P4A-dc0
Rdc37 P4A ndc37_1 8.60590944403e+13
Ldc37 ndc37_1 dc0 1
* DC[38] P4A-dc1
Rdc38 P4A ndc38_1 5.72204634944e+13
Ldc38 ndc38_1 dc1 1
* DC[42] P1B-P2B
Rdc42 P1B ndc42_1 1.63911037006
Ldc42 ndc42_1 P2B 5.44012985238e-07
* DC[43] P1B-P3B
Rdc43 P1B ndc43_1 0.00187619979207
Ldc43 ndc43_1 P3B 1.40050595997e-08
* DC[45] P1B-dc0
Rdc45 P1B ndc45_1 0.00817070811988
Ldc45 ndc45_1 dc0 1.30040858584e-09
* DC[48] P1B-dc3
Rdc48 P1B ndc48_1 0.000411918146951
Ldc48 ndc48_1 dc3 6.24821034881e-09
* DC[50] P2B-P3B
Rdc50 P2B ndc50_1 14572.6563013
Ldc50 ndc50_1 P3B 1
* DC[51] P2B-P4B
Rdc51 P2B ndc51_1 0.000760910538912
Ldc51 ndc51_1 P4B 3.4918678804e-09
* DC[53] P2B-dc1
Rdc53 P2B ndc53_1 0.000139848233373
Ldc53 ndc53_1 dc1 1.10087182226e-07
* DC[57] P3B-P4B
Rdc57 P3B ndc57_1 0.0311055222999
Ldc57 ndc57_1 P4B 7.04784601688e-08
* DC[58] P3B-dc0
Rdc58 P3B ndc58_1 0.000100203521592
Ldc58 ndc58_1 dc0 4.27831404269e-08
* DC[59] P3B-dc1
Rdc59 P3B ndc59_1 0.0564038331263
Ldc59 ndc59_1 dc1 1.5731454433e-06
* DC[60] P3B-dc2
Rdc60 P3B ndc60_1 0.0280362632279
Ldc60 ndc60_1 dc2 4.46210987854e-09
* DC[61] P3B-dc3
Rdc61 P3B ndc61_1 0.000477786231924
Ldc61 ndc61_1 dc3 7.6042040552e-11
* DC[65] P4B-dc2
Rdc65 P4B ndc65_1 0.000102954156336
Ldc65 ndc65_1 dc2 7.91417365117e-08
* DC[66] P4B-dc3
Rdc66 P4B ndc66_1 0.00276521896425
Ldc66 ndc66_1 dc3 1.3705079599e-07
* DC[68] dc0-dc1
Rdc68 dc0 ndc68_1 0.0154542181509
Ldc68 ndc68_1 dc1 2.45961521034e-09
* DC[69] dc0-dc2
Rdc69 dc0 ndc69_1 0.0193004924457
Ldc69 ndc69_1 dc2 9.77153232206e-07
* DC[70] dc0-dc3
Rdc70 dc0 ndc70_1 30477.6108144
Ldc70 ndc70_1 dc3 1
* DC[73] dc1-dc3
Rdc73 dc1 ndc73_1 0.00303347158348
Ldc73 ndc73_1 dc3 9.80259994174e-08
* DC[75] dc2-dc3
Rdc75 dc2 ndc75_1 0.0112855125868
Ldc75 ndc75_1 dc3 2.40487023839e-08
* ---- leaks
Rleak_P1A P1A GND 1e+12
Rleak_P1B P1B GND 1e+12
Rleak_P2A P2A GND 1e+12
Rleak_P2B P2B GND 1e+12
Rleak_P3A P3A GND 1e+12
Rleak_P3B P3B GND 1e+12
Rleak_P4A P4A GND 1e+12
Rleak_P4B P4B GND 1e+12
Rleak_dc0 dc0 GND 1e+12
Rleak_dc1 dc1 GND 1e+12
Rleak_dc2 dc2 GND 1e+12
Rleak_dc3 dc3 GND 1e+12
Rleak_rlc0 rlc0 GND 1e+12
Rleak_rlc1 rlc1 GND 1e+12
Rleak_rlc10 rlc10 GND 1e+12
Rleak_rlc11 rlc11 GND 1e+12
Rleak_rlc12 rlc12 GND 1e+12
Rleak_rlc13 rlc13 GND 1e+12
Rleak_rlc14 rlc14 GND 1e+12
Rleak_rlc15 rlc15 GND 1e+12
Rleak_rlc2 rlc2 GND 1e+12
Rleak_rlc3 rlc3 GND 1e+12
Rleak_rlc4 rlc4 GND 1e+12
Rleak_rlc5 rlc5 GND 1e+12
Rleak_rlc6 rlc6 GND 1e+12
Rleak_rlc7 rlc7 GND 1e+12
Rleak_rlc8 rlc8 GND 1e+12
Rleak_rlc9 rlc9 GND 1e+12
.ends fitted
