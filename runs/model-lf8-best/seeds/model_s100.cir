* fitted: 8-port fitted model, reference z0 = 50 Ohm
* every pin is a port against GND
.subckt fitted P1A P1B P2A P2B P3A P3B P4A P4B GND
* ---- branches
* RLC[1] P1A-P3A
Rrlc1 P1A nrlc1_1 4896.42296741
Lrlc1 nrlc1_1 nrlc1_2 1
Crlc1 nrlc1_2 P3A 4.63446533199e-11
* RLC[2] P1A-P4A
Rrlc2 P1A nrlc2_1 4421.36884142
Lrlc2 nrlc2_1 nrlc2_2 1
Crlc2 nrlc2_2 P4A 5.68386818878e-11
* RLC[4] P1A-P2B
Rrlc4 P1A nrlc4_1 18288.9797175
Lrlc4 nrlc4_1 nrlc4_2 1
Crlc4 nrlc4_2 P2B 3.32183865108e-12
* RLC[7] P1A-rlc0
Rrlc7 P1A nrlc7_1 83.6316344229
Lrlc7 nrlc7_1 nrlc7_2 1
Crlc7 nrlc7_2 rlc0 1.58860645134e-07
* RLC[8] P1A-rlc1
Rrlc8 P1A nrlc8_1 1700.18157119
Lrlc8 nrlc8_1 nrlc8_2 1
Crlc8 nrlc8_2 rlc1 1.16741761321e-08
* RLC[9] P1A-rlc2
Rrlc9 P1A nrlc9_1 1238.79481187
Lrlc9 nrlc9_1 nrlc9_2 1
Crlc9 nrlc9_2 rlc2 7.24033623413e-10
* RLC[10] P1A-rlc3
Rrlc10 P1A nrlc10_1 2904.78201106
Lrlc10 nrlc10_1 nrlc10_2 1
Crlc10 nrlc10_2 rlc3 1.31683207919e-10
* RLC[14] P1A-rlc7
Rrlc14 P1A nrlc14_1 5785447.10461
Lrlc14 nrlc14_1 nrlc14_2 1
Crlc14 nrlc14_2 rlc7 3.31958379648e-17
* RLC[17] P1A-rlc10
Rrlc17 P1A nrlc17_1 5862.02007767
Lrlc17 nrlc17_1 nrlc17_2 0.00293964148663
Crlc17 nrlc17_2 rlc10 9.50511236517e-14
* RLC[18] P1A-rlc11
Rrlc18 P1A nrlc18_1 10219.5788952
Lrlc18 nrlc18_1 nrlc18_2 1.97185136256e-12
Crlc18 nrlc18_2 rlc11 5.05242335464e-14
* RLC[20] P1A-rlc13
Rrlc20 P1A nrlc20_1 729.771350108
Lrlc20 nrlc20_1 nrlc20_2 1
Crlc20 nrlc20_2 rlc13 2.08633417256e-09
* RLC[21] P1A-rlc14
Rrlc21 P1A nrlc21_1 101.363885179
Lrlc21 nrlc21_1 nrlc21_2 1
Crlc21 nrlc21_2 rlc14 1.08141152575e-07
* RLC[29] P2A-P4B
Rrlc29 P2A nrlc29_1 389.875390301
Lrlc29 nrlc29_1 nrlc29_2 1.94640269112e-06
Crlc29 nrlc29_2 P4B 1.08422452002e-11
* RLC[31] P2A-rlc1
Rrlc31 P2A nrlc31_1 45978.5607188
Lrlc31 nrlc31_1 nrlc31_2 1
Crlc31 nrlc31_2 rlc1 5.25589579255e-13
* RLC[32] P2A-rlc2
Rrlc32 P2A nrlc32_1 1109.07055209
Lrlc32 nrlc32_1 nrlc32_2 1
Crlc32 nrlc32_2 rlc2 9.03314834367e-10
* RLC[33] P2A-rlc3
Rrlc33 P2A nrlc33_1 2033.12621228
Lrlc33 nrlc33_1 nrlc33_2 1
Crlc33 nrlc33_2 rlc3 2.68799719633e-10
* RLC[35] P2A-rlc5
Rrlc35 P2A nrlc35_1 88.9362435858
Lrlc35 nrlc35_1 nrlc35_2 1
Crlc35 nrlc35_2 rlc5 1.40475286428e-07
* RLC[37] P2A-rlc7
Rrlc37 P2A nrlc37_1 1366.75818073
Lrlc37 nrlc37_1 nrlc37_2 1
Crlc37 nrlc37_2 rlc7 5.94804336961e-10
* RLC[39] P2A-rlc9
Rrlc39 P2A nrlc39_1 26521.6195964
Lrlc39 nrlc39_1 nrlc39_2 1
Crlc39 nrlc39_2 rlc9 0.001
* RLC[40] P2A-rlc10
Rrlc40 P2A nrlc40_1 1556.68740959
Lrlc40 nrlc40_1 nrlc40_2 1
Crlc40 nrlc40_2 rlc10 4.58516179217e-10
* RLC[42] P2A-rlc12
Rrlc42 P2A nrlc42_1 21368.3583952
Lrlc42 nrlc42_1 nrlc42_2 1
Crlc42 nrlc42_2 rlc12 2.43340934888e-12
* RLC[43] P2A-rlc13
Rrlc43 P2A nrlc43_1 676.295031887
Lrlc43 nrlc43_1 nrlc43_2 2.18351148995e-05
Crlc43 nrlc43_2 rlc13 1.83952121054e-12
* RLC[46] P2A-GND
Rrlc46 P2A nrlc46_1 113.980121898
Lrlc46 nrlc46_1 nrlc46_2 5.1684634615e-06
Crlc46 nrlc46_2 GND 4.42039121089e-13
* RLC[47] P3A-P4A
Rrlc47 P3A nrlc47_1 3.80190087828
Lrlc47 nrlc47_1 nrlc47_2 8.14797661913e-07
Crlc47 nrlc47_2 P4A 4.38179810272e-07
* RLC[48] P3A-P1B
Rrlc48 P3A nrlc48_1 6486274.25941
Lrlc48 nrlc48_1 nrlc48_2 1
Crlc48 nrlc48_2 P1B 2.64099071608e-17
* RLC[50] P3A-P3B
Rrlc50 P3A nrlc50_1 701.368228601
Lrlc50 nrlc50_1 nrlc50_2 0.00138494502066
Crlc50 nrlc50_2 P3B 3.12822401784e-12
* RLC[51] P3A-P4B
Rrlc51 P3A nrlc51_1 6.28338152574
Lrlc51 nrlc51_1 nrlc51_2 1.75064431913e-07
Crlc51 nrlc51_2 P4B 1.32664255258e-11
* RLC[54] P3A-rlc2
Rrlc54 P3A nrlc54_1 3073.04043681
Lrlc54 nrlc54_1 nrlc54_2 1
Crlc54 nrlc54_2 rlc2 1.17657858795e-10
* RLC[55] P3A-rlc3
Rrlc55 P3A nrlc55_1 1632.20550632
Lrlc55 nrlc55_1 nrlc55_2 1
Crlc55 nrlc55_2 rlc3 4.17068906449e-10
* RLC[57] P3A-rlc5
Rrlc57 P3A nrlc57_1 1133.74356427
Lrlc57 nrlc57_1 nrlc57_2 1
Crlc57 nrlc57_2 rlc5 8.64425999937e-10
* RLC[59] P3A-rlc7
Rrlc59 P3A nrlc59_1 1242901.77711
Lrlc59 nrlc59_1 nrlc59_2 1
Crlc59 nrlc59_2 rlc7 7.19256627953e-16
* RLC[62] P3A-rlc10
Rrlc62 P3A nrlc62_1 2317.77086729
Lrlc62 nrlc62_1 nrlc62_2 1
Crlc62 nrlc62_2 rlc10 2.0683140922e-10
* RLC[63] P3A-rlc11
Rrlc63 P3A nrlc63_1 2911.65431944
Lrlc63 nrlc63_1 nrlc63_2 1
Crlc63 nrlc63_2 rlc11 1.31062324032e-10
* RLC[65] P3A-rlc13
Rrlc65 P3A nrlc65_1 27.0108444446
Lrlc65 nrlc65_1 nrlc65_2 2.18031562507e-06
Crlc65 nrlc65_2 rlc13 3.32047744118e-12
* RLC[66] P3A-rlc14
Rrlc66 P3A nrlc66_1 1996.93286836
Lrlc66 nrlc66_1 nrlc66_2 1
Crlc66 nrlc66_2 rlc14 2.78631722657e-10
* RLC[67] P3A-rlc15
Rrlc67 P3A nrlc67_1 51812.6851356
Lrlc67 nrlc67_1 nrlc67_2 1
Crlc67 nrlc67_2 rlc15 4.13890340813e-13
* RLC[69] P4A-P1B
Rrlc69 P4A nrlc69_1 672.892522312
Lrlc69 nrlc69_1 nrlc69_2 0.00377923954291
Crlc69 nrlc69_2 P1B 9.27407292094e-12
* RLC[70] P4A-P2B
Rrlc70 P4A nrlc70_1 3157.05947442
Lrlc70 nrlc70_1 nrlc70_2 3.81231620349e-05
Crlc70 nrlc70_2 P2B 4.0872872985e-12
* RLC[72] P4A-P4B
Rrlc72 P4A nrlc72_1 77605.853307
Lrlc72 nrlc72_1 nrlc72_2 0.114148881447
Crlc72 nrlc72_2 P4B 2.10591187579e-14
* RLC[73] P4A-rlc0
Rrlc73 P4A nrlc73_1 3580.18298871
Lrlc73 nrlc73_1 nrlc73_2 1
Crlc73 nrlc73_2 rlc0 8.66856163031e-11
* RLC[74] P4A-rlc1
Rrlc74 P4A nrlc74_1 7790.99213908
Lrlc74 nrlc74_1 nrlc74_2 1
Crlc74 nrlc74_2 rlc1 1.83050937826e-11
* RLC[75] P4A-rlc2
Rrlc75 P4A nrlc75_1 67535.6685271
Lrlc75 nrlc75_1 nrlc75_2 0.0177766553034
Crlc75 nrlc75_2 rlc2 8.5632616202e-13
* RLC[77] P4A-rlc4
Rrlc77 P4A nrlc77_1 2453.08203222
Lrlc77 nrlc77_1 nrlc77_2 1
Crlc77 nrlc77_2 rlc4 1.84643212525e-10
* RLC[79] P4A-rlc6
Rrlc79 P4A nrlc79_1 6937.51007671
Lrlc79 nrlc79_1 nrlc79_2 1
Crlc79 nrlc79_2 rlc6 2.30860821472e-11
* RLC[81] P4A-rlc8
Rrlc81 P4A nrlc81_1 8117.09580438
Lrlc81 nrlc81_1 nrlc81_2 8.82833582957e-13
Crlc81 nrlc81_2 rlc8 2.37480360682e-14
* RLC[82] P4A-rlc9
Rrlc82 P4A nrlc82_1 1797.25285146
Lrlc82 nrlc82_1 nrlc82_2 1
Crlc82 nrlc82_2 rlc9 3.43984701412e-10
* RLC[83] P4A-rlc10
Rrlc83 P4A nrlc83_1 4006.42227276
Lrlc83 nrlc83_1 nrlc83_2 1
Crlc83 nrlc83_2 rlc10 6.9221984767e-11
* RLC[85] P4A-rlc12
Rrlc85 P4A nrlc85_1 6081.49413446
Lrlc85 nrlc85_1 nrlc85_2 1
Crlc85 nrlc85_2 rlc12 3.00425578518e-11
* RLC[86] P4A-rlc13
Rrlc86 P4A nrlc86_1 1484.40523664
Lrlc86 nrlc86_1 nrlc86_2 1
Crlc86 nrlc86_2 rlc13 5.04257695842e-10
* RLC[87] P4A-rlc14
Rrlc87 P4A nrlc87_1 215.539024122
Lrlc87 nrlc87_1 nrlc87_2 3.30217392449e-06
Crlc87 nrlc87_2 rlc14 7.89779051008e-14
* RLC[90] P1B-P2B
Rrlc90 P1B nrlc90_1 0.1963771259
Lrlc90 nrlc90_1 nrlc90_2 1.79152554206e-07
Crlc90 nrlc90_2 P2B 1.9680049363e-05
* RLC[92] P1B-P4B
Rrlc92 P1B nrlc92_1 21.2051078543
Lrlc92 nrlc92_1 nrlc92_2 2.06619617322e-10
Crlc92 nrlc92_2 P4B 2.5199815216e-11
* RLC[93] P1B-rlc0
Rrlc93 P1B nrlc93_1 1091.17969073
Lrlc93 nrlc93_1 nrlc93_2 1
Crlc93 nrlc93_2 rlc0 9.3317896811e-10
* RLC[94] P1B-rlc1
Rrlc94 P1B nrlc94_1 445.953920438
Lrlc94 nrlc94_1 nrlc94_2 1
Crlc94 nrlc94_2 rlc1 5.58698516422e-09
* RLC[95] P1B-rlc2
Rrlc95 P1B nrlc95_1 36685.669168
Lrlc95 nrlc95_1 nrlc95_2 1
Crlc95 nrlc95_2 rlc2 0.001
* RLC[97] P1B-rlc4
Rrlc97 P1B nrlc97_1 49.5017061064
Lrlc97 nrlc97_1 nrlc97_2 1
Crlc97 nrlc97_2 rlc4 4.53437209342e-07
* RLC[99] P1B-rlc6
Rrlc99 P1B nrlc99_1 47.3915216193
Lrlc99 nrlc99_1 nrlc99_2 1
Crlc99 nrlc99_2 rlc6 4.94716259852e-07
* RLC[106] P1B-rlc13
Rrlc106 P1B nrlc106_1 68.95472815
Lrlc106 nrlc106_1 nrlc106_2 1
Crlc106 nrlc106_2 rlc13 2.33684221364e-07
* RLC[108] P1B-rlc15
Rrlc108 P1B nrlc108_1 9.87839279355
Lrlc108 nrlc108_1 nrlc108_2 4.55854921842e-07
Crlc108 nrlc108_2 rlc15 5.19052822303e-12
* RLC[113] P2B-rlc1
Rrlc113 P2B nrlc113_1 644.049448461
Lrlc113 nrlc113_1 nrlc113_2 1
Crlc113 nrlc113_2 rlc1 2.67866908383e-09
* RLC[114] P2B-rlc2
Rrlc114 P2B nrlc114_1 6.05361685035
Lrlc114 nrlc114_1 nrlc114_2 5.74154483442e-09
Crlc114 nrlc114_2 rlc2 1.74083011639e-13
* RLC[116] P2B-rlc4
Rrlc116 P2B nrlc116_1 218.726999757
Lrlc116 nrlc116_1 nrlc116_2 1
Crlc116 nrlc116_2 rlc4 2.3224838295e-08
* RLC[119] P2B-rlc7
Rrlc119 P2B nrlc119_1 501354.469332
Lrlc119 nrlc119_1 nrlc119_2 0.223979552037
Crlc119 nrlc119_2 rlc7 9.90093206536e-16
* RLC[120] P2B-rlc8
Rrlc120 P2B nrlc120_1 139.170086259
Lrlc120 nrlc120_1 nrlc120_2 1
Crlc120 nrlc120_2 rlc8 5.73674700691e-08
* RLC[121] P2B-rlc9
Rrlc121 P2B nrlc121_1 248.829799126
Lrlc121 nrlc121_1 nrlc121_2 1
Crlc121 nrlc121_2 rlc9 1.79453822114e-08
* RLC[123] P2B-rlc11
Rrlc123 P2B nrlc123_1 37.8826571504
Lrlc123 nrlc123_1 nrlc123_2 1
Crlc123 nrlc123_2 rlc11 7.74241816223e-07
* RLC[124] P2B-rlc12
Rrlc124 P2B nrlc124_1 22706.4739893
Lrlc124 nrlc124_1 nrlc124_2 1
Crlc124 nrlc124_2 rlc12 0.001
* RLC[125] P2B-rlc13
Rrlc125 P2B nrlc125_1 143.362250007
Lrlc125 nrlc125_1 nrlc125_2 1
Crlc125 nrlc125_2 rlc13 5.40614728823e-08
* RLC[130] P3B-rlc0
Rrlc130 P3B nrlc130_1 28597.7511095
Lrlc130 nrlc130_1 nrlc130_2 0.0180661749967
Crlc130 nrlc130_2 rlc0 2.4544824944e-14
* RLC[131] P3B-rlc1
Rrlc131 P3B nrlc131_1 790.072331164
Lrlc131 nrlc131_1 nrlc131_2 1
Crlc131 nrlc131_2 rlc1 1.7800155037e-09
* RLC[132] P3B-rlc2
Rrlc132 P3B nrlc132_1 9975.07841525
Lrlc132 nrlc132_1 nrlc132_2 0.00362010192098
Crlc132 nrlc132_2 rlc2 4.04245925884e-14
* RLC[133] P3B-rlc3
Rrlc133 P3B nrlc133_1 202.90997937
Lrlc133 nrlc133_1 nrlc133_2 1
Crlc133 nrlc133_2 rlc3 2.69867556724e-08
* RLC[136] P3B-rlc6
Rrlc136 P3B nrlc136_1 10416.5890155
Lrlc136 nrlc136_1 nrlc136_2 1
Crlc136 nrlc136_2 rlc6 1.02401526702e-11
* RLC[137] P3B-rlc7
Rrlc137 P3B nrlc137_1 767.46595591
Lrlc137 nrlc137_1 nrlc137_2 1
Crlc137 nrlc137_2 rlc7 1.88642373126e-09
* RLC[138] P3B-rlc8
Rrlc138 P3B nrlc138_1 63.0957260614
Lrlc138 nrlc138_1 nrlc138_2 1
Crlc138 nrlc138_2 rlc8 2.79098566585e-07
* RLC[140] P3B-rlc10
Rrlc140 P3B nrlc140_1 1744.11765754
Lrlc140 nrlc140_1 nrlc140_2 0.000144993209627
Crlc140 nrlc140_2 rlc10 5.29606853279e-14
* RLC[142] P3B-rlc12
Rrlc142 P3B nrlc142_1 22706.4975404
Lrlc142 nrlc142_1 nrlc142_2 1
Crlc142 nrlc142_2 rlc12 0.001
* RLC[143] P3B-rlc13
Rrlc143 P3B nrlc143_1 2238.19050678
Lrlc143 nrlc143_1 nrlc143_2 1
Crlc143 nrlc143_2 rlc13 2.21800944836e-10
* RLC[144] P3B-rlc14
Rrlc144 P3B nrlc144_1 530.737448524
Lrlc144 nrlc144_1 nrlc144_2 1
Crlc144 nrlc144_2 rlc14 6.3396212881e-08
* RLC[145] P3B-rlc15
Rrlc145 P3B nrlc145_1 39152.8005041
Lrlc145 nrlc145_1 nrlc145_2 0.00306542945144
Crlc145 nrlc145_2 rlc15 2.63507853723e-13
* RLC[147] P4B-rlc0
Rrlc147 P4B nrlc147_1 44606.1952561
Lrlc147 nrlc147_1 nrlc147_2 0.239913864888
Crlc147 nrlc147_2 rlc0 1.33974601954e-13
* RLC[149] P4B-rlc2
Rrlc149 P4B nrlc149_1 36687.3895083
Lrlc149 nrlc149_1 nrlc149_2 1
Crlc149 nrlc149_2 rlc2 0.001
* RLC[153] P4B-rlc6
Rrlc153 P4B nrlc153_1 315.65781892
Lrlc153 nrlc153_1 nrlc153_2 1
Crlc153 nrlc153_2 rlc6 1.11512714512e-08
* RLC[155] P4B-rlc8
Rrlc155 P4B nrlc155_1 23315.487139
Lrlc155 nrlc155_1 nrlc155_2 1
Crlc155 nrlc155_2 rlc8 0.001
* RLC[156] P4B-rlc9
Rrlc156 P4B nrlc156_1 32429.1877821
Lrlc156 nrlc156_1 nrlc156_2 1
Crlc156 nrlc156_2 rlc9 1.05653854931e-12
* RLC[157] P4B-rlc10
Rrlc157 P4B nrlc157_1 218.591391903
Lrlc157 nrlc157_1 nrlc157_2 2.47154471442e-05
Crlc157 nrlc157_2 rlc10 5.74724685844e-13
* RLC[158] P4B-rlc11
Rrlc158 P4B nrlc158_1 11780.3801557
Lrlc158 nrlc158_1 nrlc158_2 1
Crlc158 nrlc158_2 rlc11 0.001
* RLC[159] P4B-rlc12
Rrlc159 P4B nrlc159_1 22706.4959156
Lrlc159 nrlc159_1 nrlc159_2 1
Crlc159 nrlc159_2 rlc12 0.001
* RLC[160] P4B-rlc13
Rrlc160 P4B nrlc160_1 101936.816146
Lrlc160 nrlc160_1 nrlc160_2 1
Crlc160 nrlc160_2 rlc13 1.06928964416e-13
* RLC[161] P4B-rlc14
Rrlc161 P4B nrlc161_1 78.5774098608
Lrlc161 nrlc161_1 nrlc161_2 1
Crlc161 nrlc161_2 rlc14 1.79954235272e-07
* RLC[162] P4B-rlc15
Rrlc162 P4B nrlc162_1 4594.7141238
Lrlc162 nrlc162_1 nrlc162_2 1
Crlc162 nrlc162_2 rlc15 5.26308640222e-11
* RLC[164] rlc0-rlc1
Rrlc164 rlc0 nrlc164_1 19.8486197723
Lrlc164 nrlc164_1 nrlc164_2 0.0666884673886
Crlc164 nrlc164_2 rlc1 1.88082159546e-07
* RLC[165] rlc0-rlc2
Rrlc165 rlc0 nrlc165_1 1.05409255339
Lrlc165 nrlc165_1 nrlc165_2 1
Crlc165 nrlc165_2 rlc2 0.001
* RLC[166] rlc0-rlc3
Rrlc166 rlc0 nrlc166_1 4806.1712228
Lrlc166 nrlc166_1 nrlc166_2 1
Crlc166 nrlc166_2 rlc3 4.81015435731e-11
* RLC[167] rlc0-rlc4
Rrlc167 rlc0 nrlc167_1 34.2904811471
Lrlc167 nrlc167_1 nrlc167_2 1
Crlc167 nrlc167_2 rlc4 9.44953270874e-07
* RLC[169] rlc0-rlc6
Rrlc169 rlc0 nrlc169_1 284.064768415
Lrlc169 nrlc169_1 nrlc169_2 1
Crlc169 nrlc169_2 rlc6 1.49831192594e-08
* RLC[170] rlc0-rlc7
Rrlc170 rlc0 nrlc170_1 8.91048191635
Lrlc170 nrlc170_1 nrlc170_2 1
Crlc170 nrlc170_2 rlc7 1.39944264598e-05
* RLC[172] rlc0-rlc9
Rrlc172 rlc0 nrlc172_1 0.0116415862568
Lrlc172 nrlc172_1 nrlc172_2 1.21431378424e-08
Crlc172 nrlc172_2 rlc9 9.95552333804e-08
* RLC[173] rlc0-rlc10
Rrlc173 rlc0 nrlc173_1 1.05409255339
Lrlc173 nrlc173_1 nrlc173_2 1
Crlc173 nrlc173_2 rlc10 0.001
* RLC[174] rlc0-rlc11
Rrlc174 rlc0 nrlc174_1 31408.0742219
Lrlc174 nrlc174_1 nrlc174_2 1
Crlc174 nrlc174_2 rlc11 0.001
* RLC[175] rlc0-rlc12
Rrlc175 rlc0 nrlc175_1 1.05409255339
Lrlc175 nrlc175_1 nrlc175_2 1
Crlc175 nrlc175_2 rlc12 0.001
* RLC[176] rlc0-rlc13
Rrlc176 rlc0 nrlc176_1 1.05409255339
Lrlc176 nrlc176_1 nrlc176_2 1
Crlc176 nrlc176_2 rlc13 0.001
* RLC[177] rlc0-rlc14
Rrlc177 rlc0 nrlc177_1 284.021775201
Lrlc177 nrlc177_1 nrlc177_2 1
Crlc177 nrlc177_2 rlc14 1.37738140464e-08
* RLC[178] rlc0-rlc15
Rrlc178 rlc0 nrlc178_1 1.44701531302
Lrlc178 nrlc178_1 nrlc178_2 1
Crlc178 nrlc178_2 rlc15 0.000530653748554
* RLC[179] rlc0-GND
Rrlc179 rlc0 nrlc179_1 9.75033783412
Lrlc179 nrlc179_1 nrlc179_2 1
Crlc179 nrlc179_2 GND 1.16874068732e-05
* RLC[180] rlc1-rlc2
Rrlc180 rlc1 nrlc180_1 8.27451853133
Lrlc180 nrlc180_1 nrlc180_2 2.66208086724e-09
Crlc180 nrlc180_2 rlc2 4.32009471784e-14
* RLC[183] rlc1-rlc5
Rrlc183 rlc1 nrlc183_1 117822.746398
Lrlc183 nrlc183_1 nrlc183_2 1
Crlc183 nrlc183_2 rlc5 8.00385490506e-14
* RLC[185] rlc1-rlc7
Rrlc185 rlc1 nrlc185_1 0.0115333794621
Lrlc185 nrlc185_1 nrlc185_2 8.51477290248e-10
Crlc185 nrlc185_2 rlc7 7.11242005367e-09
* RLC[186] rlc1-rlc8
Rrlc186 rlc1 nrlc186_1 54.8195888105
Lrlc186 nrlc186_1 nrlc186_2 1
Crlc186 nrlc186_2 rlc8 3.69731066245e-07
* RLC[187] rlc1-rlc9
Rrlc187 rlc1 nrlc187_1 46005.1024404
Lrlc187 nrlc187_1 nrlc187_2 1
Crlc187 nrlc187_2 rlc9 0.001
* RLC[188] rlc1-rlc10
Rrlc188 rlc1 nrlc188_1 155.860126759
Lrlc188 nrlc188_1 nrlc188_2 1
Crlc188 nrlc188_2 rlc10 4.57390816243e-08
* RLC[189] rlc1-rlc11
Rrlc189 rlc1 nrlc189_1 2368.3104114
Lrlc189 nrlc189_1 nrlc189_2 1
Crlc189 nrlc189_2 rlc11 1.98098068986e-10
* RLC[191] rlc1-rlc13
Rrlc191 rlc1 nrlc191_1 136.420160945
Lrlc191 nrlc191_1 nrlc191_2 1
Crlc191 nrlc191_2 rlc13 5.97035802702e-08
* RLC[192] rlc1-rlc14
Rrlc192 rlc1 nrlc192_1 43815.3678919
Lrlc192 nrlc192_1 nrlc192_2 1
Crlc192 nrlc192_2 rlc14 5.78768072511e-13
* RLC[195] rlc2-rlc3
Rrlc195 rlc2 nrlc195_1 26.445114149
Lrlc195 nrlc195_1 nrlc195_2 1
Crlc195 nrlc195_2 rlc3 1.58879036932e-06
* RLC[196] rlc2-rlc4
Rrlc196 rlc2 nrlc196_1 3.24316314453
Lrlc196 nrlc196_1 nrlc196_2 0.00476750106446
Crlc196 nrlc196_2 rlc4 5.03628962253e-07
* RLC[197] rlc2-rlc5
Rrlc197 rlc2 nrlc197_1 41.7488768336
Lrlc197 nrlc197_1 nrlc197_2 0.0378754435195
Crlc197 nrlc197_2 rlc5 2.41449119112e-08
* RLC[199] rlc2-rlc7
Rrlc199 rlc2 nrlc199_1 1.05409255339
Lrlc199 nrlc199_1 nrlc199_2 1
Crlc199 nrlc199_2 rlc7 0.001
* RLC[201] rlc2-rlc9
Rrlc201 rlc2 nrlc201_1 1.05409255339
Lrlc201 nrlc201_1 nrlc201_2 1
Crlc201 nrlc201_2 rlc9 0.001
* RLC[202] rlc2-rlc10
Rrlc202 rlc2 nrlc202_1 609166.701524
Lrlc202 nrlc202_1 nrlc202_2 0.71445932161
Crlc202 nrlc202_2 rlc10 2.13925564132e-15
* RLC[205] rlc2-rlc13
Rrlc205 rlc2 nrlc205_1 4.30598038354
Lrlc205 nrlc205_1 nrlc205_2 1
Crlc205 nrlc205_2 rlc13 5.99257387408e-05
* RLC[207] rlc2-rlc15
Rrlc207 rlc2 nrlc207_1 5268.85964167
Lrlc207 nrlc207_1 nrlc207_2 1
Crlc207 nrlc207_2 rlc15 4.00243448377e-11
* RLC[208] rlc2-GND
Rrlc208 rlc2 nrlc208_1 7.4021182768
Lrlc208 nrlc208_1 nrlc208_2 0.000850269335882
Crlc208 nrlc208_2 GND 1.72425687741e-08
* RLC[209] rlc3-rlc4
Rrlc209 rlc3 nrlc209_1 4.84153832191
Lrlc209 nrlc209_1 nrlc209_2 1
Crlc209 nrlc209_2 rlc4 4.7401353539e-05
* RLC[210] rlc3-rlc5
Rrlc210 rlc3 nrlc210_1 738.355099501
Lrlc210 nrlc210_1 nrlc210_2 0.000100942935961
Crlc210 nrlc210_2 rlc5 2.05732481901e-13
* RLC[211] rlc3-rlc6
Rrlc211 rlc3 nrlc211_1 0.13321011203
Lrlc211 nrlc211_1 nrlc211_2 0.0159704405523
Crlc211 nrlc211_2 rlc6 0.001
* RLC[212] rlc3-rlc7
Rrlc212 rlc3 nrlc212_1 4.64469452841
Lrlc212 nrlc212_1 nrlc212_2 1
Crlc212 nrlc212_2 rlc7 5.15042630281e-05
* RLC[215] rlc3-rlc10
Rrlc215 rlc3 nrlc215_1 122.926276637
Lrlc215 nrlc215_1 nrlc215_2 1
Crlc215 nrlc215_2 rlc10 7.35305875019e-08
* RLC[216] rlc3-rlc11
Rrlc216 rlc3 nrlc216_1 30.5929749412
Lrlc216 nrlc216_1 nrlc216_2 1
Crlc216 nrlc216_2 rlc11 1.18717315792e-06
* RLC[217] rlc3-rlc12
Rrlc217 rlc3 nrlc217_1 19188.233577
Lrlc217 nrlc217_1 nrlc217_2 1
Crlc217 nrlc217_2 rlc12 3.01777945565e-12
* RLC[218] rlc3-rlc13
Rrlc218 rlc3 nrlc218_1 42.5647990325
Lrlc218 nrlc218_1 nrlc218_2 1
Crlc218 nrlc218_2 rlc13 6.13276489713e-07
* RLC[219] rlc3-rlc14
Rrlc219 rlc3 nrlc219_1 77.5247040352
Lrlc219 nrlc219_1 nrlc219_2 1
Crlc219 nrlc219_2 rlc14 1.84874603993e-07
* RLC[220] rlc3-rlc15
Rrlc220 rlc3 nrlc220_1 4.01213367633
Lrlc220 nrlc220_1 nrlc220_2 0.44841185878
Crlc220 nrlc220_2 rlc15 3.09516489644e-05
* RLC[221] rlc3-GND
Rrlc221 rlc3 nrlc221_1 4.16967435704
Lrlc221 nrlc221_1 nrlc221_2 1
Crlc221 nrlc221_2 GND 6.39077036992e-05
* RLC[222] rlc4-rlc5
Rrlc222 rlc4 nrlc222_1 0.0586283268284
Lrlc222 nrlc222_1 nrlc222_2 0.00309355263603
Crlc222 nrlc222_2 rlc5 0.001
* RLC[225] rlc4-rlc8
Rrlc225 rlc4 nrlc225_1 0.0120638057304
Lrlc225 nrlc225_1 nrlc225_2 1.40824218466e-12
Crlc225 nrlc225_2 rlc8 1.07514284838e-11
* RLC[230] rlc4-rlc13
Rrlc230 rlc4 nrlc230_1 955.633107267
Lrlc230 nrlc230_1 nrlc230_2 2.186269584e-10
Crlc230 nrlc230_2 rlc13 6.47173411907e-13
* RLC[232] rlc4-rlc15
Rrlc232 rlc4 nrlc232_1 4.00951479937
Lrlc232 nrlc232_1 nrlc232_2 1
Crlc232 nrlc232_2 rlc15 6.91152445331e-05
* RLC[233] rlc4-GND
Rrlc233 rlc4 nrlc233_1 0.0001
Lrlc233 nrlc233_1 nrlc233_2 1.36199994818e-10
Crlc233 nrlc233_2 GND 2.02930026365e-05
* RLC[235] rlc5-rlc7
Rrlc235 rlc5 nrlc235_1 30.0203049272
Lrlc235 nrlc235_1 nrlc235_2 1
Crlc235 nrlc235_2 rlc7 1.23289840895e-06
* RLC[236] rlc5-rlc8
Rrlc236 rlc5 nrlc236_1 0.0438207798631
Lrlc236 nrlc236_1 nrlc236_2 0.000355176038132
Crlc236 nrlc236_2 rlc8 0.000205513778699
* RLC[237] rlc5-rlc9
Rrlc237 rlc5 nrlc237_1 54.5161263207
Lrlc237 nrlc237_1 nrlc237_2 1
Crlc237 nrlc237_2 rlc9 3.73858717831e-07
* RLC[240] rlc5-rlc12
Rrlc240 rlc5 nrlc240_1 4.64673531138
Lrlc240 nrlc240_1 nrlc240_2 0.303610917551
Crlc240 nrlc240_2 rlc12 1.5623524231e-05
* RLC[242] rlc5-rlc14
Rrlc242 rlc5 nrlc242_1 16.1108875303
Lrlc242 nrlc242_1 nrlc242_2 1
Crlc242 nrlc242_2 rlc14 4.28073712195e-06
* RLC[243] rlc5-rlc15
Rrlc243 rlc5 nrlc243_1 0.152187538427
Lrlc243 nrlc243_1 nrlc243_2 7.53186191116e-10
Crlc243 nrlc243_2 rlc15 3.61328031077e-11
* RLC[244] rlc5-GND
Rrlc244 rlc5 nrlc244_1 0.00030551689572
Lrlc244 nrlc244_1 nrlc244_2 3.01605257846e-11
Crlc244 nrlc244_2 GND 3.59026027314e-07
* RLC[245] rlc6-rlc7
Rrlc245 rlc6 nrlc245_1 1.05409255339
Lrlc245 nrlc245_1 nrlc245_2 1
Crlc245 nrlc245_2 rlc7 0.001
* RLC[246] rlc6-rlc8
Rrlc246 rlc6 nrlc246_1 0.118982562461
Lrlc246 nrlc246_1 nrlc246_2 8.05016334737e-10
Crlc246 nrlc246_2 rlc8 6.31823169296e-11
* RLC[247] rlc6-rlc9
Rrlc247 rlc6 nrlc247_1 4787.1025103
Lrlc247 nrlc247_1 nrlc247_2 1
Crlc247 nrlc247_2 rlc9 4.84855175269e-11
* RLC[248] rlc6-rlc10
Rrlc248 rlc6 nrlc248_1 69.699748404
Lrlc248 nrlc248_1 nrlc248_2 0.00428158823138
Crlc248 nrlc248_2 rlc10 9.79264402731e-10
* RLC[249] rlc6-rlc11
Rrlc249 rlc6 nrlc249_1 16.7237512181
Lrlc249 nrlc249_1 nrlc249_2 1
Crlc249 nrlc249_2 rlc11 3.97273954869e-06
* RLC[250] rlc6-rlc12
Rrlc250 rlc6 nrlc250_1 302800.407695
Lrlc250 nrlc250_1 nrlc250_2 0.011667825701
Crlc250 nrlc250_2 rlc12 1.41395149765e-16
* RLC[251] rlc6-rlc13
Rrlc251 rlc6 nrlc251_1 42.3269269183
Lrlc251 nrlc251_1 nrlc251_2 1
Crlc251 nrlc251_2 rlc13 6.20188935455e-07
* RLC[254] rlc6-GND
Rrlc254 rlc6 nrlc254_1 1.05409255339
Lrlc254 nrlc254_1 nrlc254_2 1
Crlc254 nrlc254_2 GND 0.001
* RLC[257] rlc7-rlc10
Rrlc257 rlc7 nrlc257_1 1517.60835945
Lrlc257 nrlc257_1 nrlc257_2 1
Crlc257 nrlc257_2 rlc10 4.82434180847e-10
* RLC[258] rlc7-rlc11
Rrlc258 rlc7 nrlc258_1 276.911092747
Lrlc258 nrlc258_1 nrlc258_2 0.00293080015289
Crlc258 nrlc258_2 rlc11 4.24681154379e-11
* RLC[259] rlc7-rlc12
Rrlc259 rlc7 nrlc259_1 156.553758238
Lrlc259 nrlc259_1 nrlc259_2 8.0503717583e-07
Crlc259 nrlc259_2 rlc12 3.64960977502e-14
* RLC[260] rlc7-rlc13
Rrlc260 rlc7 nrlc260_1 6235.38013121
Lrlc260 nrlc260_1 nrlc260_2 1
Crlc260 nrlc260_2 rlc13 2.8577986123e-11
* RLC[261] rlc7-rlc14
Rrlc261 rlc7 nrlc261_1 364.248628312
Lrlc261 nrlc261_1 nrlc261_2 1
Crlc261 nrlc261_2 rlc14 8.37455309971e-09
* RLC[263] rlc7-GND
Rrlc263 rlc7 nrlc263_1 155.591209713
Lrlc263 nrlc263_1 nrlc263_2 1
Crlc263 nrlc263_2 GND 4.58973251158e-08
* RLC[264] rlc8-rlc9
Rrlc264 rlc8 nrlc264_1 11.4747441011
Lrlc264 nrlc264_1 nrlc264_2 1
Crlc264 nrlc264_2 rlc9 0.000116308498609
* RLC[267] rlc8-rlc12
Rrlc267 rlc8 nrlc267_1 0.768019274053
Lrlc267 nrlc267_1 nrlc267_2 0.00107296339326
Crlc267 nrlc267_2 rlc12 2.02114819224e-06
* RLC[268] rlc8-rlc13
Rrlc268 rlc8 nrlc268_1 14.2548036845
Lrlc268 nrlc268_1 nrlc268_2 1
Crlc268 nrlc268_2 rlc13 5.4680818819e-06
* RLC[270] rlc8-rlc15
Rrlc270 rlc8 nrlc270_1 4729.32468267
Lrlc270 nrlc270_1 nrlc270_2 1
Crlc270 nrlc270_2 rlc15 4.96774424814e-11
* RLC[274] rlc9-rlc12
Rrlc274 rlc9 nrlc274_1 1.57170646263
Lrlc274 nrlc274_1 nrlc274_2 1
Crlc274 nrlc274_2 rlc12 0.000449794988892
* RLC[275] rlc9-rlc13
Rrlc275 rlc9 nrlc275_1 271.671461957
Lrlc275 nrlc275_1 nrlc275_2 0.0362097954983
Crlc275 nrlc275_2 rlc13 5.45124276061e-10
* RLC[276] rlc9-rlc14
Rrlc276 rlc9 nrlc276_1 2.15494116769
Lrlc276 nrlc276_1 nrlc276_2 0.0372227677294
Crlc276 nrlc276_2 rlc14 8.90625892741e-06
* RLC[277] rlc9-rlc15
Rrlc277 rlc9 nrlc277_1 14.0537485069
Lrlc277 nrlc277_1 nrlc277_2 1
Crlc277 nrlc277_2 rlc15 5.62565552438e-06
* RLC[278] rlc9-GND
Rrlc278 rlc9 nrlc278_1 0.398968952899
Lrlc278 nrlc278_1 nrlc278_2 6.18734061139e-10
Crlc278 nrlc278_2 GND 4.31900108528e-12
* RLC[280] rlc10-rlc12
Rrlc280 rlc10 nrlc280_1 19109.6301775
Lrlc280 nrlc280_1 nrlc280_2 1
Crlc280 nrlc280_2 rlc12 3.04265650181e-12
* RLC[281] rlc10-rlc13
Rrlc281 rlc10 nrlc281_1 20014.8541635
Lrlc281 nrlc281_1 nrlc281_2 1
Crlc281 nrlc281_2 rlc13 2.77365621351e-12
* RLC[282] rlc10-rlc14
Rrlc282 rlc10 nrlc282_1 3.01589771574
Lrlc282 nrlc282_1 nrlc282_2 1
Crlc282 nrlc282_2 rlc14 0.000122158663864
* RLC[283] rlc10-rlc15
Rrlc283 rlc10 nrlc283_1 0.358511302753
Lrlc283 nrlc283_1 nrlc283_2 0.115677318782
Crlc283 nrlc283_2 rlc15 0.001
* RLC[284] rlc10-GND
Rrlc284 rlc10 nrlc284_1 1.05459215674
Lrlc284 nrlc284_1 nrlc284_2 1
Crlc284 nrlc284_2 GND 0.001
* RLC[285] rlc11-rlc12
Rrlc285 rlc11 nrlc285_1 3616.25276595
Lrlc285 nrlc285_1 nrlc285_2 1
Crlc285 nrlc285_2 rlc12 0.001
* RLC[286] rlc11-rlc13
Rrlc286 rlc11 nrlc286_1 42.3778761894
Lrlc286 nrlc286_1 nrlc286_2 1
Crlc286 nrlc286_2 rlc13 6.18698573861e-07
* RLC[288] rlc11-rlc15
Rrlc288 rlc11 nrlc288_1 0.0192147020051
Lrlc288 nrlc288_1 nrlc288_2 1.549467787e-12
Crlc288 nrlc288_2 rlc15 4.66307859401e-12
* RLC[290] rlc12-rlc13
Rrlc290 rlc12 nrlc290_1 309.189383247
Lrlc290 nrlc290_1 nrlc290_2 1
Crlc290 nrlc290_2 rlc13 1.16227352324e-08
* RLC[292] rlc12-rlc15
Rrlc292 rlc12 nrlc292_1 1353.11140084
Lrlc292 nrlc292_1 nrlc292_2 1
Crlc292 nrlc292_2 rlc15 6.06862614809e-10
* RLC[294] rlc13-rlc14
Rrlc294 rlc13 nrlc294_1 5986.84282599
Lrlc294 nrlc294_1 nrlc294_2 1
Crlc294 nrlc294_2 rlc14 3.10000059537e-11
* RLC[295] rlc13-rlc15
Rrlc295 rlc13 nrlc295_1 33.3441789234
Lrlc295 nrlc295_1 nrlc295_2 1
Crlc295 nrlc295_2 rlc15 9.99349582049e-07
* RLC[296] rlc13-GND
Rrlc296 rlc13 nrlc296_1 73.7186117028
Lrlc296 nrlc296_1 nrlc296_2 1
Crlc296 nrlc296_2 GND 2.04457570028e-07
* RLC[297] rlc14-rlc15
Rrlc297 rlc14 nrlc297_1 164.442607529
Lrlc297 nrlc297_1 nrlc297_2 1
Crlc297 nrlc297_2 rlc15 4.10893036485e-08
* RLC[298] rlc14-GND
Rrlc298 rlc14 nrlc298_1 39.5041737121
Lrlc298 nrlc298_1 nrlc298_2 1
Crlc298 nrlc298_2 GND 7.11986117817e-07
* RLC[299] rlc15-GND
Rrlc299 rlc15 nrlc299_1 673.843413005
Lrlc299 nrlc299_1 nrlc299_2 0.00203792004996
Crlc299 nrlc299_2 GND 4.98685404974e-12
* DC[0] P1A-P2A
Rdc0 P1A ndc0_1 0.0859091034476
Ldc0 ndc0_1 P2A 1.05726651503e-07
* DC[23] P3A-P4A
Rdc23 P3A ndc23_1 0.129900947961
Ldc23 ndc23_1 P4A 1.8358982116e-07
* DC[43] P1B-P3B
Rdc43 P1B ndc43_1 0.000618618960828
Ldc43 ndc43_1 P3B 3.8230724982e-09
* DC[47] P1B-dc2
Rdc47 P1B ndc47_1 0.0001
Ldc47 ndc47_1 dc2 3.44234103609e-07
* DC[48] P1B-dc3
Rdc48 P1B ndc48_1 0.0001
Ldc48 ndc48_1 dc3 1.2655284937e-07
* DC[51] P2B-P4B
Rdc51 P2B ndc51_1 0.000750179719952
Ldc51 ndc51_1 P4B 4.18986656646e-09
* DC[52] P2B-dc0
Rdc52 P2B ndc52_1 0.00477521716651
Ldc52 ndc52_1 dc0 4.81922687408e-08
* DC[54] P2B-dc2
Rdc54 P2B ndc54_1 0.00676881825503
Ldc54 ndc54_1 dc2 1.07729088418e-09
* DC[57] P3B-P4B
Rdc57 P3B ndc57_1 0.0179891073916
Ldc57 ndc57_1 P4B 4.9090341072e-08
* DC[58] P3B-dc0
Rdc58 P3B ndc58_1 0.0001
Ldc58 ndc58_1 dc0 7.54500598071e-08
* DC[63] P4B-dc0
Rdc63 P4B ndc63_1 0.00399488594096
Ldc63 ndc63_1 dc0 6.35805844591e-10
* DC[65] P4B-dc2
Rdc65 P4B ndc65_1 0.00473154872109
Ldc65 ndc65_1 dc2 2.55131502719e-08
* DC[72] dc1-dc2
Rdc72 dc1 ndc72_1 0.0001
Ldc72 ndc72_1 dc2 1.34147980891e-06
* DC[73] dc1-dc3
Rdc73 dc1 ndc73_1 0.0001
Ldc73 ndc73_1 dc3 3.20738273437e-11
* DC[75] dc2-dc3
Rdc75 dc2 ndc75_1 0.0001
Ldc75 ndc75_1 dc3 6.70755966117e-07
* ---- leaks
Rleak_P1A P1A GND 1e+12
Rleak_P1B P1B GND 1e+12
Rleak_P2A P2A GND 1e+12
Rleak_P2B P2B GND 1e+12
Rleak_P3A P3A GND 1e+12
Rleak_P3B P3B GND 1e+12
Rleak_P4A P4A GND 1e+12
Rleak_P4B P4B GND 1e+12
Rleak_dc0 dc0 GND 1e+12
Rleak_dc1 dc1 GND 1e+12
Rleak_dc2 dc2 GND 1e+12
Rleak_dc3 dc3 GND 1e+12
Rleak_rlc0 rlc0 GND 1e+12
Rleak_rlc1 rlc1 GND 1e+12
Rleak_rlc10 rlc10 GND 1e+12
Rleak_rlc11 rlc11 GND 1e+12
Rleak_rlc12 rlc12 GND 1e+12
Rleak_rlc13 rlc13 GND 1e+12
Rleak_rlc14 rlc14 GND 1e+12
Rleak_rlc15 rlc15 GND 1e+12
Rleak_rlc2 rlc2 GND 1e+12
Rleak_rlc3 rlc3 GND 1e+12
Rleak_rlc4 rlc4 GND 1e+12
Rleak_rlc5 rlc5 GND 1e+12
Rleak_rlc6 rlc6 GND 1e+12
Rleak_rlc7 rlc7 GND 1e+12
Rleak_rlc8 rlc8 GND 1e+12
Rleak_rlc9 rlc9 GND 1e+12
.ends fitted
