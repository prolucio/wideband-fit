* fitted: 8-port fitted model, reference z0 = 50 Ohm
* every pin is a port against GND
.subckt fitted P1A P1B P2A P2B P3A P3B P4A P4B GND
* ---- branches
* RLC[0] P1A-P2A
Rrlc0 P1A nrlc0_1 0.787385757757
Lrlc0 nrlc0_1 nrlc0_2 2.99998422933e-07
Crlc0 nrlc0_2 P2A 2.90993785047e-06
* RLC[1] P1A-P3A
Rrlc1 P1A nrlc1_1 2.9218963451e+13
Lrlc1 nrlc1_1 nrlc1_2 0.891091453406
Crlc1 nrlc1_2 P3A 2.46276874891e-10
* RLC[2] P1A-P4A
Rrlc2 P1A nrlc2_1 416.603068145
Lrlc2 nrlc2_1 nrlc2_2 7.46139063084e-07
Crlc2 nrlc2_2 P4A 1.67083541704e-12
* RLC[3] P1A-P1B
Rrlc3 P1A nrlc3_1 5676.04245202
Lrlc3 nrlc3_1 nrlc3_2 1
Crlc3 nrlc3_2 P1B 3.44878579176e-11
* RLC[4] P1A-P2B
Rrlc4 P1A nrlc4_1 3.3275825856e+12
Lrlc4 nrlc4_1 nrlc4_2 0.884166776336
Crlc4 nrlc4_2 P2B 1.89969593562e-06
* RLC[5] P1A-P3B
Rrlc5 P1A nrlc5_1 275.767460569
Lrlc5 nrlc5_1 nrlc5_2 0.00218967183657
Crlc5 nrlc5_2 P3B 8.18491894593e-11
* RLC[6] P1A-P4B
Rrlc6 P1A nrlc6_1 7646.74010364
Lrlc6 nrlc6_1 nrlc6_2 1
Crlc6 nrlc6_2 P4B 1.90022414087e-11
* RLC[7] P1A-rlc0
Rrlc7 P1A nrlc7_1 8677.10944675
Lrlc7 nrlc7_1 nrlc7_2 1
Crlc7 nrlc7_2 rlc0 1.47573147382e-11
* RLC[13] P1A-rlc6
Rrlc13 P1A nrlc13_1 38.7455163941
Lrlc13 nrlc13_1 nrlc13_2 8.70772115725e-09
Crlc13 nrlc13_2 rlc6 9.43092256915e-14
* RLC[14] P1A-rlc7
Rrlc14 P1A nrlc14_1 1822.79064629
Lrlc14 nrlc14_1 nrlc14_2 0.000182931125486
Crlc14 nrlc14_2 rlc7 5.53675491981e-12
* RLC[17] P1A-rlc10
Rrlc17 P1A nrlc17_1 3222.70041851
Lrlc17 nrlc17_1 nrlc17_2 1
Crlc17 nrlc17_2 rlc10 1.0698370144e-10
* RLC[20] P1A-rlc13
Rrlc20 P1A nrlc20_1 3495.95215419
Lrlc20 nrlc20_1 nrlc20_2 1
Crlc20 nrlc20_2 rlc13 9.09131132527e-11
* RLC[21] P1A-rlc14
Rrlc21 P1A nrlc21_1 2840.20484831
Lrlc21 nrlc21_1 nrlc21_2 1
Crlc21 nrlc21_2 rlc14 1.37739392018e-10
* RLC[24] P2A-P3A
Rrlc24 P2A nrlc24_1 3.31098229427e+13
Lrlc24 nrlc24_1 nrlc24_2 0.808890848897
Crlc24 nrlc24_2 P3A 1.09114610978e-08
* RLC[25] P2A-P4A
Rrlc25 P2A nrlc25_1 9.98744464396e+12
Lrlc25 nrlc25_1 nrlc25_2 0.193393269474
Crlc25 nrlc25_2 P4A 8.98891782956e-08
* RLC[26] P2A-P1B
Rrlc26 P2A nrlc26_1 414408762020
Lrlc26 nrlc26_1 nrlc26_2 0.999866590952
Crlc26 nrlc26_2 P1B 2.53491295301e-11
* RLC[27] P2A-P2B
Rrlc27 P2A nrlc27_1 49.874759381
Lrlc27 nrlc27_1 nrlc27_2 2.61160820077e-07
Crlc27 nrlc27_2 P2B 9.83162601088e-12
* RLC[28] P2A-P3B
Rrlc28 P2A nrlc28_1 8.93867563824e+12
Lrlc28 nrlc28_1 nrlc28_2 0.896272370346
Crlc28 nrlc28_2 P3B 1.23324738816e-08
* RLC[29] P2A-P4B
Rrlc29 P2A nrlc29_1 811197892181
Lrlc29 nrlc29_1 nrlc29_2 0.000641751491045
Crlc29 nrlc29_2 P4B 1.73295298013e-09
* RLC[30] P2A-rlc0
Rrlc30 P2A nrlc30_1 4414.60515384
Lrlc30 nrlc30_1 nrlc30_2 1
Crlc30 nrlc30_2 rlc0 5.70129822278e-11
* RLC[31] P2A-rlc1
Rrlc31 P2A nrlc31_1 15183.0532653
Lrlc31 nrlc31_1 nrlc31_2 0.0677129198412
Crlc31 nrlc31_2 rlc1 3.26370427748e-13
* RLC[32] P2A-rlc2
Rrlc32 P2A nrlc32_1 2619.28643175
Lrlc32 nrlc32_1 nrlc32_2 1
Crlc32 nrlc32_2 rlc2 1.61953934826e-10
* RLC[35] P2A-rlc5
Rrlc35 P2A nrlc35_1 3961.88397727
Lrlc35 nrlc35_1 nrlc35_2 1
Crlc35 nrlc35_2 rlc5 7.07870777724e-11
* RLC[36] P2A-rlc6
Rrlc36 P2A nrlc36_1 2829.81061869
Lrlc36 nrlc36_1 nrlc36_2 1
Crlc36 nrlc36_2 rlc6 1.38753116577e-10
* RLC[38] P2A-rlc8
Rrlc38 P2A nrlc38_1 1826.25466676
Lrlc38 nrlc38_1 nrlc38_2 1
Crlc38 nrlc38_2 rlc8 3.33146161039e-10
* RLC[39] P2A-rlc9
Rrlc39 P2A nrlc39_1 5116.13293869
Lrlc39 nrlc39_1 nrlc39_2 1
Crlc39 nrlc39_2 rlc9 4.24496241217e-11
* RLC[40] P2A-rlc10
Rrlc40 P2A nrlc40_1 10194.5315296
Lrlc40 nrlc40_1 nrlc40_2 1
Crlc40 nrlc40_2 rlc10 1.06911135889e-11
* RLC[41] P2A-rlc11
Rrlc41 P2A nrlc41_1 1301.21991703
Lrlc41 nrlc41_1 nrlc41_2 1
Crlc41 nrlc41_2 rlc11 6.56230008571e-10
* RLC[45] P2A-rlc15
Rrlc45 P2A nrlc45_1 131114.97201
Lrlc45 nrlc45_1 nrlc45_2 0.546329294709
Crlc45 nrlc45_2 rlc15 3.53107877064e-14
* RLC[47] P3A-P4A
Rrlc47 P3A nrlc47_1 3.88663795473
Lrlc47 nrlc47_1 nrlc47_2 8.16943308855e-07
Crlc47 nrlc47_2 P4A 4.2650736284e-07
* RLC[48] P3A-P1B
Rrlc48 P3A nrlc48_1 9.72335458816e+12
Lrlc48 nrlc48_1 nrlc48_2 0.999999147349
Crlc48 nrlc48_2 P1B 3.27993574207e-06
* RLC[49] P3A-P2B
Rrlc49 P3A nrlc49_1 10.0980141918
Lrlc49 nrlc49_1 nrlc49_2 5.75271963518e-07
Crlc49 nrlc49_2 P2B 6.26842950118e-12
* RLC[50] P3A-P3B
Rrlc50 P3A nrlc50_1 69670.3291637
Lrlc50 nrlc50_1 nrlc50_2 0.0107357024201
Crlc50 nrlc50_2 P3B 2.45749266735e-15
* RLC[51] P3A-P4B
Rrlc51 P3A nrlc51_1 300869.655222
Lrlc51 nrlc51_1 nrlc51_2 0.755321760784
Crlc51 nrlc51_2 P4B 1.08282094042e-14
* RLC[58] P3A-rlc6
Rrlc58 P3A nrlc58_1 1693485.27083
Lrlc58 nrlc58_1 nrlc58_2 0.231901419437
Crlc58 nrlc58_2 rlc6 8.98458558577e-17
* RLC[59] P3A-rlc7
Rrlc59 P3A nrlc59_1 924.806689354
Lrlc59 nrlc59_1 nrlc59_2 1
Crlc59 nrlc59_2 rlc7 1.29913883617e-09
* RLC[61] P3A-rlc9
Rrlc61 P3A nrlc61_1 3102.21215095
Lrlc61 nrlc61_1 nrlc61_2 1
Crlc61 nrlc61_2 rlc9 1.15455466765e-10
* RLC[62] P3A-rlc10
Rrlc62 P3A nrlc62_1 4540.71306353
Lrlc62 nrlc62_1 nrlc62_2 1
Crlc62 nrlc62_2 rlc10 5.38901475699e-11
* RLC[63] P3A-rlc11
Rrlc63 P3A nrlc63_1 652235.460474
Lrlc63 nrlc63_1 nrlc63_2 0.126257532204
Crlc63 nrlc63_2 rlc11 3.29766073911e-16
* RLC[69] P4A-P1B
Rrlc69 P4A nrlc69_1 8.01277393473
Lrlc69 nrlc69_1 nrlc69_2 3.24931016987e-07
Crlc69 nrlc69_2 P1B 5.623191582e-12
* RLC[70] P4A-P2B
Rrlc70 P4A nrlc70_1 8359.57256825
Lrlc70 nrlc70_1 nrlc70_2 0.000315526052874
Crlc70 nrlc70_2 P2B 3.76968223944e-12
* RLC[71] P4A-P3B
Rrlc71 P4A nrlc71_1 4472.42847109
Lrlc71 nrlc71_1 nrlc71_2 0.0150649746206
Crlc71 nrlc71_2 P3B 1.01792422747e-12
* RLC[72] P4A-P4B
Rrlc72 P4A nrlc72_1 6.30513534695e+12
Lrlc72 nrlc72_1 nrlc72_2 0.00674569242725
Crlc72 nrlc72_2 P4B 1.73673189671e-07
* RLC[78] P4A-rlc5
Rrlc78 P4A nrlc78_1 1.02594779771
Lrlc78 nrlc78_1 nrlc78_2 4.51609025759e-11
Crlc78 nrlc78_2 rlc5 1.71005230091e-13
* RLC[80] P4A-rlc7
Rrlc80 P4A nrlc80_1 5.10828531166
Lrlc80 nrlc80_1 nrlc80_2 1.46484432127e-10
Crlc80 nrlc80_2 rlc7 2.14381026039e-12
* RLC[81] P4A-rlc8
Rrlc81 P4A nrlc81_1 165286.519483
Lrlc81 nrlc81_1 nrlc81_2 0.0643114026652
Crlc81 nrlc81_2 rlc8 2.61559563061e-15
* RLC[82] P4A-rlc9
Rrlc82 P4A nrlc82_1 34264.5554916
Lrlc82 nrlc82_1 nrlc82_2 1
Crlc82 nrlc82_2 rlc9 9.46383775421e-13
* RLC[84] P4A-rlc11
Rrlc84 P4A nrlc84_1 14731.5508013
Lrlc84 nrlc84_1 nrlc84_2 1
Crlc84 nrlc84_2 rlc11 5.11988911257e-12
* RLC[85] P4A-rlc12
Rrlc85 P4A nrlc85_1 66113.240798
Lrlc85 nrlc85_1 nrlc85_2 0.118782444788
Crlc85 nrlc85_2 rlc12 3.01948486891e-14
* RLC[86] P4A-rlc13
Rrlc86 P4A nrlc86_1 96586.5650291
Lrlc86 nrlc86_1 nrlc86_2 1
Crlc86 nrlc86_2 rlc13 1.19103369496e-13
* RLC[88] P4A-rlc15
Rrlc88 P4A nrlc88_1 44873.3246969
Lrlc88 nrlc88_1 nrlc88_2 0.327689662966
Crlc88 nrlc88_2 rlc15 1.8081886399e-13
* RLC[91] P1B-P3B
Rrlc91 P1B nrlc91_1 5419.29390289
Lrlc91 nrlc91_1 nrlc91_2 1.66143074157e-07
Crlc91 nrlc91_2 P3B 0.000991747429301
* RLC[92] P1B-P4B
Rrlc92 P1B nrlc92_1 7.33862821632
Lrlc92 nrlc92_1 nrlc92_2 1.43421062234e-07
Crlc92 nrlc92_2 P4B 1.67835090425e-11
* RLC[93] P1B-rlc0
Rrlc93 P1B nrlc93_1 3060.64189705
Lrlc93 nrlc93_1 nrlc93_2 1
Crlc93 nrlc93_2 rlc0 1.18613044296e-10
* RLC[94] P1B-rlc1
Rrlc94 P1B nrlc94_1 87158.5538825
Lrlc94 nrlc94_1 nrlc94_2 1
Crlc94 nrlc94_2 rlc1 1.46264004209e-13
* RLC[97] P1B-rlc4
Rrlc97 P1B nrlc97_1 65051.4759263
Lrlc97 nrlc97_1 nrlc97_2 0.148372194716
Crlc97 nrlc97_2 rlc4 3.89579146941e-14
* RLC[100] P1B-rlc7
Rrlc100 P1B nrlc100_1 9.25508234418
Lrlc100 nrlc100_1 nrlc100_2 1.17444779303e-06
Crlc100 nrlc100_2 rlc7 1.52345851482e-11
* RLC[101] P1B-rlc8
Rrlc101 P1B nrlc101_1 294551.419701
Lrlc101 nrlc101_1 nrlc101_2 0.255393695871
Crlc101 nrlc101_2 rlc8 3.27073548595e-15
* RLC[102] P1B-rlc9
Rrlc102 P1B nrlc102_1 6834.87043897
Lrlc102 nrlc102_1 nrlc102_2 1
Crlc102 nrlc102_2 rlc9 2.37846583504e-11
* RLC[103] P1B-rlc10
Rrlc103 P1B nrlc103_1 544.596917675
Lrlc103 nrlc103_1 nrlc103_2 1
Crlc103 nrlc103_2 rlc10 3.74633951066e-09
* RLC[107] P1B-rlc14
Rrlc107 P1B nrlc107_1 988.165252823
Lrlc107 nrlc107_1 nrlc107_2 1
Crlc107 nrlc107_2 rlc14 1.1378848977e-09
* RLC[111] P2B-P4B
Rrlc111 P2B nrlc111_1 0.00874292348978
Lrlc111 nrlc111_1 nrlc111_2 9.21465538358e-08
Crlc111 nrlc111_2 P4B 0.001
* RLC[112] P2B-rlc0
Rrlc112 P2B nrlc112_1 292563.479246
Lrlc112 nrlc112_1 nrlc112_2 0.128064265965
Crlc112 nrlc112_2 rlc0 1.6624371329e-15
* RLC[114] P2B-rlc2
Rrlc114 P2B nrlc114_1 767.603197491
Lrlc114 nrlc114_1 nrlc114_2 1
Crlc114 nrlc114_2 rlc2 1.88574923529e-09
* RLC[116] P2B-rlc4
Rrlc116 P2B nrlc116_1 1754.09071705
Lrlc116 nrlc116_1 nrlc116_2 1
Crlc116 nrlc116_2 rlc4 3.61121536983e-10
* RLC[118] P2B-rlc6
Rrlc118 P2B nrlc118_1 16356.3018134
Lrlc118 nrlc118_1 nrlc118_2 0.0467246616177
Crlc118 nrlc118_2 rlc6 1.94058836841e-13
* RLC[125] P2B-rlc13
Rrlc125 P2B nrlc125_1 3330.88098664
Lrlc125 nrlc125_1 nrlc125_2 3.09942317532e-12
Crlc125 nrlc125_2 rlc13 5.69617641073e-13
* RLC[129] P3B-P4B
Rrlc129 P3B nrlc129_1 0.0154252317318
Lrlc129 nrlc129_1 nrlc129_2 4.34501874422e-08
Crlc129 nrlc129_2 P4B 0.001
* RLC[132] P3B-rlc2
Rrlc132 P3B nrlc132_1 715.786922816
Lrlc132 nrlc132_1 nrlc132_2 1
Crlc132 nrlc132_2 rlc2 2.16865251955e-09
* RLC[135] P3B-rlc5
Rrlc135 P3B nrlc135_1 575.831874514
Lrlc135 nrlc135_1 nrlc135_2 1
Crlc135 nrlc135_2 rlc5 3.35093565384e-09
* RLC[136] P3B-rlc6
Rrlc136 P3B nrlc136_1 17247.6453141
Lrlc136 nrlc136_1 nrlc136_2 0.36834994364
Crlc136 nrlc136_2 rlc6 1.37581003569e-12
* RLC[137] P3B-rlc7
Rrlc137 P3B nrlc137_1 6595.91863778
Lrlc137 nrlc137_1 nrlc137_2 1
Crlc137 nrlc137_2 rlc7 2.5539177752e-11
* RLC[138] P3B-rlc8
Rrlc138 P3B nrlc138_1 632.416823367
Lrlc138 nrlc138_1 nrlc138_2 1
Crlc138 nrlc138_2 rlc8 2.77811782998e-09
* RLC[140] P3B-rlc10
Rrlc140 P3B nrlc140_1 1305.07018771
Lrlc140 nrlc140_1 nrlc140_2 1
Crlc140 nrlc140_2 rlc10 6.52363647895e-10
* RLC[141] P3B-rlc11
Rrlc141 P3B nrlc141_1 0.00375958247216
Lrlc141 nrlc141_1 nrlc141_2 4.92902283484e-14
Crlc141 nrlc141_2 rlc11 7.72784064248e-12
* RLC[145] P3B-rlc15
Rrlc145 P3B nrlc145_1 378.491267836
Lrlc145 nrlc145_1 nrlc145_2 1
Crlc145 nrlc145_2 rlc15 7.75614218361e-09
* RLC[150] P4B-rlc3
Rrlc150 P4B nrlc150_1 23767.7845491
Lrlc150 nrlc150_1 nrlc150_2 1
Crlc150 nrlc150_2 rlc3 1.96689006447e-12
* RLC[154] P4B-rlc7
Rrlc154 P4B nrlc154_1 788.312481275
Lrlc154 nrlc154_1 nrlc154_2 4.91950859344e-07
Crlc154 nrlc154_2 rlc7 2.42957787915e-12
* RLC[155] P4B-rlc8
Rrlc155 P4B nrlc155_1 12505.4561053
Lrlc155 nrlc155_1 nrlc155_2 0.105213368919
Crlc155 nrlc155_2 rlc8 7.4753123687e-13
* RLC[156] P4B-rlc9
Rrlc156 P4B nrlc156_1 2770.24414283
Lrlc156 nrlc156_1 nrlc156_2 1
Crlc156 nrlc156_2 rlc9 1.44784276391e-10
* RLC[158] P4B-rlc11
Rrlc158 P4B nrlc158_1 1399.76237538
Lrlc158 nrlc158_1 nrlc158_2 1
Crlc158 nrlc158_2 rlc11 5.67085912804e-10
* RLC[160] P4B-rlc13
Rrlc160 P4B nrlc160_1 213207.5774
Lrlc160 nrlc160_1 nrlc160_2 0.292612233909
Crlc160 nrlc160_2 rlc13 7.15228315073e-15
* RLC[161] P4B-rlc14
Rrlc161 P4B nrlc161_1 1957.25809422
Lrlc161 nrlc161_1 nrlc161_2 1
Crlc161 nrlc161_2 rlc14 2.90042269726e-10
* RLC[162] P4B-rlc15
Rrlc162 P4B nrlc162_1 3316.86356982
Lrlc162 nrlc162_1 nrlc162_2 1
Crlc162 nrlc162_2 rlc15 1.00995558193e-10
* RLC[163] P4B-GND
Rrlc163 P4B nrlc163_1 6238.61659615
Lrlc163 nrlc163_1 nrlc163_2 1
Crlc163 nrlc163_2 GND 2.85483424809e-11
* RLC[164] rlc0-rlc1
Rrlc164 rlc0 nrlc164_1 4.44848900553
Lrlc164 nrlc164_1 nrlc164_2 1
Crlc164 nrlc164_2 rlc1 5.61477616282e-05
* RLC[165] rlc0-rlc2
Rrlc165 rlc0 nrlc165_1 28.6829317266
Lrlc165 nrlc165_1 nrlc165_2 0.183922571274
Crlc165 nrlc165_2 rlc2 2.48396482766e-07
* RLC[166] rlc0-rlc3
Rrlc166 rlc0 nrlc166_1 4.31825745724
Lrlc166 nrlc166_1 nrlc166_2 1
Crlc166 nrlc166_2 rlc3 5.95854779388e-05
* RLC[167] rlc0-rlc4
Rrlc167 rlc0 nrlc167_1 1.67568774282
Lrlc167 nrlc167_1 nrlc167_2 0.00518502053582
Crlc167 nrlc167_2 rlc4 2.05173744939e-06
* RLC[169] rlc0-rlc6
Rrlc169 rlc0 nrlc169_1 13.5035150984
Lrlc169 nrlc169_1 nrlc169_2 1.37436739173e-05
Crlc169 nrlc169_2 rlc6 8.37464997428e-11
* RLC[170] rlc0-rlc7
Rrlc170 rlc0 nrlc170_1 1605167.18304
Lrlc170 nrlc170_1 nrlc170_2 0.98210502827
Crlc170 nrlc170_2 rlc7 4.23520933081e-16
* RLC[171] rlc0-rlc8
Rrlc171 rlc0 nrlc171_1 1.31113135634
Lrlc171 nrlc171_1 nrlc171_2 0.0982748493902
Crlc171 nrlc171_2 rlc8 6.35195583413e-05
* RLC[172] rlc0-rlc9
Rrlc172 rlc0 nrlc172_1 0.429799450561
Lrlc172 nrlc172_1 nrlc172_2 0.00316905464891
Crlc172 nrlc172_2 rlc9 1.90614312521e-05
* RLC[173] rlc0-rlc10
Rrlc173 rlc0 nrlc173_1 2.50444367068
Lrlc173 nrlc173_1 nrlc173_2 1
Crlc173 nrlc173_2 rlc10 0.000177147470084
* RLC[176] rlc0-rlc13
Rrlc176 rlc0 nrlc176_1 17.1293399515
Lrlc176 nrlc176_1 nrlc176_2 0.126595170971
Crlc176 nrlc176_2 rlc13 4.79394859855e-07
* RLC[177] rlc0-rlc14
Rrlc177 rlc0 nrlc177_1 18632.5377129
Lrlc177 nrlc177_1 nrlc177_2 0.0950075493328
Crlc177 nrlc177_2 rlc14 3.04068609816e-13
* RLC[178] rlc0-rlc15
Rrlc178 rlc0 nrlc178_1 0.00338915295438
Lrlc178 nrlc178_1 nrlc178_2 1.63047523953e-11
Crlc178 nrlc178_2 rlc15 2.95935237495e-09
* RLC[179] rlc0-GND
Rrlc179 rlc0 nrlc179_1 0.000615151653534
Lrlc179 nrlc179_1 nrlc179_2 3.80320485778e-15
Crlc179 nrlc179_2 GND 2.63258230648e-11
* RLC[180] rlc1-rlc2
Rrlc180 rlc1 nrlc180_1 1.07947606984
Lrlc180 nrlc180_1 nrlc180_2 1
Crlc180 nrlc180_2 rlc2 0.00095352361256
* RLC[181] rlc1-rlc3
Rrlc181 rlc1 nrlc181_1 0.775496786427
Lrlc181 nrlc181_1 nrlc181_2 0.424108150329
Crlc181 nrlc181_2 rlc3 0.000783563331762
* RLC[182] rlc1-rlc4
Rrlc182 rlc1 nrlc182_1 0.402832911614
Lrlc182 nrlc182_1 nrlc182_2 0.146046919212
Crlc182 nrlc182_2 rlc4 0.001
* RLC[183] rlc1-rlc5
Rrlc183 rlc1 nrlc183_1 2.88547638277
Lrlc183 nrlc183_1 nrlc183_2 1
Crlc183 nrlc183_2 rlc5 0.000133451187458
* RLC[184] rlc1-rlc6
Rrlc184 rlc1 nrlc184_1 198.481597078
Lrlc184 nrlc184_1 nrlc184_2 0.381265323756
Crlc184 nrlc184_2 rlc6 1.07533630061e-08
* RLC[185] rlc1-rlc7
Rrlc185 rlc1 nrlc185_1 5.69303064035
Lrlc185 nrlc185_1 nrlc185_2 1
Crlc185 nrlc185_2 rlc7 3.42823392367e-05
* RLC[188] rlc1-rlc10
Rrlc188 rlc1 nrlc188_1 3.15902779323
Lrlc188 nrlc188_1 nrlc188_2 1
Crlc188 nrlc188_2 rlc10 0.000111339841018
* RLC[189] rlc1-rlc11
Rrlc189 rlc1 nrlc189_1 5.45582182122
Lrlc189 nrlc189_1 nrlc189_2 1
Crlc189 nrlc189_2 rlc11 3.73282073258e-05
* RLC[191] rlc1-rlc13
Rrlc191 rlc1 nrlc191_1 2.75158233459
Lrlc191 nrlc191_1 nrlc191_2 1
Crlc191 nrlc191_2 rlc13 0.000146754850862
* RLC[192] rlc1-rlc14
Rrlc192 rlc1 nrlc192_1 845.926144383
Lrlc192 nrlc192_1 nrlc192_2 1
Crlc192 nrlc192_2 rlc14 1.55271802787e-09
* RLC[194] rlc1-GND
Rrlc194 rlc1 nrlc194_1 348.279396233
Lrlc194 nrlc194_1 nrlc194_2 1
Crlc194 nrlc194_2 GND 9.16013606506e-09
* RLC[196] rlc2-rlc4
Rrlc196 rlc2 nrlc196_1 70.0983646132
Lrlc196 nrlc196_1 nrlc196_2 0.0577025595394
Crlc196 nrlc196_2 rlc4 1.30477851329e-08
* RLC[197] rlc2-rlc5
Rrlc197 rlc2 nrlc197_1 0.0077425509447
Lrlc197 nrlc197_1 nrlc197_2 2.29410147717e-05
Crlc197 nrlc197_2 rlc5 0.000425208533578
* RLC[198] rlc2-rlc6
Rrlc198 rlc2 nrlc198_1 14.9476932401
Lrlc198 nrlc198_1 nrlc198_2 1
Crlc198 nrlc198_2 rlc6 4.9728932591e-06
* RLC[199] rlc2-rlc7
Rrlc199 rlc2 nrlc199_1 15.3632976761
Lrlc199 nrlc199_1 nrlc199_2 1
Crlc199 nrlc199_2 rlc7 4.70748125866e-06
* RLC[207] rlc2-rlc15
Rrlc207 rlc2 nrlc207_1 187.859772903
Lrlc207 nrlc207_1 nrlc207_2 0.385916527617
Crlc207 nrlc207_2 rlc15 1.2150195979e-08
* RLC[208] rlc2-GND
Rrlc208 rlc2 nrlc208_1 36.5404216867
Lrlc208 nrlc208_1 nrlc208_2 1
Crlc208 nrlc208_2 GND 8.32166791289e-07
* RLC[211] rlc3-rlc6
Rrlc211 rlc3 nrlc211_1 0.256082301483
Lrlc211 nrlc211_1 nrlc211_2 0.0242883031038
Crlc211 nrlc211_2 rlc6 0.000411524348455
* RLC[212] rlc3-rlc7
Rrlc212 rlc3 nrlc212_1 363.271766876
Lrlc212 nrlc212_1 nrlc212_2 1.40899300745e-05
Crlc212 nrlc212_2 rlc7 1.18632323345e-13
* RLC[213] rlc3-rlc8
Rrlc213 rlc3 nrlc213_1 1.11967460076
Lrlc213 nrlc213_1 nrlc213_2 1
Crlc213 nrlc213_2 rlc8 0.000886285894449
* RLC[214] rlc3-rlc9
Rrlc214 rlc3 nrlc214_1 3.52674519009
Lrlc214 nrlc214_1 nrlc214_2 1
Crlc214 nrlc214_2 rlc9 8.93324664938e-05
* RLC[215] rlc3-rlc10
Rrlc215 rlc3 nrlc215_1 117.760492244
Lrlc215 nrlc215_1 nrlc215_2 3.26726032444e-06
Crlc215 nrlc215_2 rlc10 2.61783340246e-13
* RLC[216] rlc3-rlc11
Rrlc216 rlc3 nrlc216_1 3.44380512819
Lrlc216 nrlc216_1 nrlc216_2 1
Crlc216 nrlc216_2 rlc11 9.36872203265e-05
* RLC[218] rlc3-rlc13
Rrlc218 rlc3 nrlc218_1 1.05409255339
Lrlc218 nrlc218_1 nrlc218_2 1
Crlc218 nrlc218_2 rlc13 0.001
* RLC[219] rlc3-rlc14
Rrlc219 rlc3 nrlc219_1 4.45233996538
Lrlc219 nrlc219_1 nrlc219_2 1
Crlc219 nrlc219_2 rlc14 5.605067593e-05
* RLC[221] rlc3-GND
Rrlc221 rlc3 nrlc221_1 87.525342558
Lrlc221 nrlc221_1 nrlc221_2 1
Crlc221 nrlc221_2 GND 1.4504068834e-07
* RLC[222] rlc4-rlc5
Rrlc222 rlc4 nrlc222_1 16530.5081066
Lrlc222 nrlc222_1 nrlc222_2 6.82924797359e-06
Crlc222 nrlc222_2 rlc5 7.91047855987e-14
* RLC[224] rlc4-rlc7
Rrlc224 rlc4 nrlc224_1 12.9923690945
Lrlc224 nrlc224_1 nrlc224_2 0.742155396425
Crlc224 nrlc224_2 rlc7 4.88512454851e-06
* RLC[225] rlc4-rlc8
Rrlc225 rlc4 nrlc225_1 0.876380115907
Lrlc225 nrlc225_1 nrlc225_2 0.0564028511128
Crlc225 nrlc225_2 rlc8 8.15968733396e-05
* RLC[227] rlc4-rlc10
Rrlc227 rlc4 nrlc227_1 1.05409255339
Lrlc227 nrlc227_1 nrlc227_2 1
Crlc227 nrlc227_2 rlc10 0.001
* RLC[228] rlc4-rlc11
Rrlc228 rlc4 nrlc228_1 5.5910599117
Lrlc228 nrlc228_1 nrlc228_2 0.0211925564527
Crlc228 nrlc228_2 rlc11 7.53273253547e-07
* RLC[229] rlc4-rlc12
Rrlc229 rlc4 nrlc229_1 0.109982104223
Lrlc229 nrlc229_1 nrlc229_2 1.16563394087e-06
Crlc229 nrlc229_2 rlc12 1.07071928816e-07
* RLC[233] rlc4-GND
Rrlc233 rlc4 nrlc233_1 1.27089858269
Lrlc233 nrlc233_1 nrlc233_2 1
Crlc233 nrlc233_2 GND 0.000687916457995
* RLC[234] rlc5-rlc6
Rrlc234 rlc5 nrlc234_1 8.32646697991
Lrlc234 nrlc234_1 nrlc234_2 0.903728884692
Crlc234 nrlc234_2 rlc6 1.44835200742e-05
* RLC[235] rlc5-rlc7
Rrlc235 rlc5 nrlc235_1 3.04640056183
Lrlc235 nrlc235_1 nrlc235_2 1
Crlc235 nrlc235_2 rlc7 0.000119724622667
* RLC[236] rlc5-rlc8
Rrlc236 rlc5 nrlc236_1 152.07434646
Lrlc236 nrlc236_1 nrlc236_2 3.99223346664e-07
Crlc236 nrlc236_2 rlc8 6.19177211124e-14
* RLC[238] rlc5-rlc10
Rrlc238 rlc5 nrlc238_1 4.84270225737
Lrlc238 nrlc238_1 nrlc238_2 1
Crlc238 nrlc238_2 rlc10 4.73785706038e-05
* RLC[243] rlc5-rlc15
Rrlc243 rlc5 nrlc243_1 284.589323892
Lrlc243 nrlc243_1 nrlc243_2 0.58463576841
Crlc243 nrlc243_2 rlc15 8.02057796955e-09
* RLC[244] rlc5-GND
Rrlc244 rlc5 nrlc244_1 277.227135475
Lrlc244 nrlc244_1 nrlc244_2 1
Crlc244 nrlc244_2 GND 1.44572608008e-08
* RLC[245] rlc6-rlc7
Rrlc245 rlc6 nrlc245_1 96468.2481263
Lrlc245 nrlc245_1 nrlc245_2 1
Crlc245 nrlc245_2 rlc7 1.19395705759e-13
* RLC[246] rlc6-rlc8
Rrlc246 rlc6 nrlc246_1 25.8818360212
Lrlc246 nrlc246_1 nrlc246_2 1
Crlc246 nrlc246_2 rlc8 1.65869802634e-06
* RLC[247] rlc6-rlc9
Rrlc247 rlc6 nrlc247_1 2.46193542252
Lrlc247 nrlc247_1 nrlc247_2 0.322195200116
Crlc247 nrlc247_2 rlc9 5.90640526758e-05
* RLC[248] rlc6-rlc10
Rrlc248 rlc6 nrlc248_1 22.9065728818
Lrlc248 nrlc248_1 nrlc248_2 1
Crlc248 nrlc248_2 rlc10 2.11756745939e-06
* RLC[249] rlc6-rlc11
Rrlc249 rlc6 nrlc249_1 1173.35454784
Lrlc249 nrlc249_1 nrlc249_2 0.0024253751142
Crlc249 nrlc249_2 rlc11 1.95739234599e-12
* RLC[250] rlc6-rlc12
Rrlc250 rlc6 nrlc250_1 20.0581104511
Lrlc250 nrlc250_1 nrlc250_2 4.48246505887e-07
Crlc250 nrlc250_2 rlc12 1.23792509381e-12
* RLC[252] rlc6-rlc14
Rrlc252 rlc6 nrlc252_1 301.343094354
Lrlc252 nrlc252_1 nrlc252_2 1
Crlc252 nrlc252_2 rlc14 1.22358742072e-08
* RLC[253] rlc6-rlc15
Rrlc253 rlc6 nrlc253_1 43.0605882675
Lrlc253 nrlc253_1 nrlc253_2 8.65226542055e-06
Crlc253 nrlc253_2 rlc15 5.18474506555e-12
* RLC[254] rlc6-GND
Rrlc254 rlc6 nrlc254_1 4.66105984335
Lrlc254 nrlc254_1 nrlc254_2 0.318199365006
Crlc254 nrlc254_2 GND 1.62737425597e-05
* RLC[255] rlc7-rlc8
Rrlc255 rlc7 nrlc255_1 4.28768423637
Lrlc255 nrlc255_1 nrlc255_2 0.56631330999
Crlc255 nrlc255_2 rlc8 3.42269870397e-05
* RLC[256] rlc7-rlc9
Rrlc256 rlc7 nrlc256_1 0.705320785299
Lrlc256 nrlc256_1 nrlc256_2 0.155764046258
Crlc256 nrlc256_2 rlc9 0.000347897530559
* RLC[258] rlc7-rlc11
Rrlc258 rlc7 nrlc258_1 0.632366700511
Lrlc258 nrlc258_1 nrlc258_2 0.153409336472
Crlc258 nrlc258_2 rlc11 0.000426256777112
* RLC[259] rlc7-rlc12
Rrlc259 rlc7 nrlc259_1 4745.66910586
Lrlc259 nrlc259_1 nrlc259_2 1
Crlc259 nrlc259_2 rlc12 4.93358464202e-11
* RLC[260] rlc7-rlc13
Rrlc260 rlc7 nrlc260_1 5.06271781365
Lrlc260 nrlc260_1 nrlc260_2 0.558801377334
Crlc260 nrlc260_2 rlc13 2.42240924811e-05
* RLC[261] rlc7-rlc14
Rrlc261 rlc7 nrlc261_1 7147.54761136
Lrlc261 nrlc261_1 nrlc261_2 1
Crlc261 nrlc261_2 rlc14 2.17492044909e-11
* RLC[262] rlc7-rlc15
Rrlc262 rlc7 nrlc262_1 41.2840153428
Lrlc262 nrlc262_1 nrlc262_2 0.853299187164
Crlc262 nrlc262_2 rlc15 5.56281940478e-07
* RLC[263] rlc7-GND
Rrlc263 rlc7 nrlc263_1 17.9559532942
Lrlc263 nrlc263_1 nrlc263_2 1
Crlc263 nrlc263_2 GND 3.44620062147e-06
* RLC[264] rlc8-rlc9
Rrlc264 rlc8 nrlc264_1 6.65117607291
Lrlc264 nrlc264_1 nrlc264_2 0.181079163757
Crlc264 nrlc264_2 rlc9 4.54809032437e-06
* RLC[268] rlc8-rlc13
Rrlc268 rlc8 nrlc268_1 0.303327832798
Lrlc268 nrlc268_1 nrlc268_2 2.20640847141e-05
Crlc268 nrlc268_2 rlc13 2.66451937445e-07
* RLC[270] rlc8-rlc15
Rrlc270 rlc8 nrlc270_1 44.3539422709
Lrlc270 nrlc270_1 nrlc270_2 0.166384783311
Crlc270 nrlc270_2 rlc15 9.39737683118e-08
* RLC[271] rlc8-GND
Rrlc271 rlc8 nrlc271_1 1.5403467579
Lrlc271 nrlc271_1 nrlc271_2 1
Crlc271 nrlc271_2 GND 0.000468296048198
* RLC[273] rlc9-rlc11
Rrlc273 rlc9 nrlc273_1 0.0102625116714
Lrlc273 nrlc273_1 nrlc273_2 1.17519928396e-06
Crlc273 nrlc273_2 rlc11 1.2398286866e-05
* RLC[275] rlc9-rlc13
Rrlc275 rlc9 nrlc275_1 12.0310656583
Lrlc275 nrlc275_1 nrlc275_2 0.184118195808
Crlc275 nrlc275_2 rlc13 1.41333790696e-06
* RLC[276] rlc9-rlc14
Rrlc276 rlc9 nrlc276_1 2.38060825887
Lrlc276 nrlc276_1 nrlc276_2 0.00711565828234
Crlc276 nrlc276_2 rlc14 1.39507225734e-06
* RLC[278] rlc9-GND
Rrlc278 rlc9 nrlc278_1 1.33639870792
Lrlc278 nrlc278_1 nrlc278_2 1
Crlc278 nrlc278_2 GND 0.000622136091427
* RLC[279] rlc10-rlc11
Rrlc279 rlc10 nrlc279_1 1801.5723391
Lrlc279 nrlc279_1 nrlc279_2 0.717854899716
Crlc279 nrlc279_2 rlc11 2.4574842845e-10
* RLC[280] rlc10-rlc12
Rrlc280 rlc10 nrlc280_1 4.67151378944
Lrlc280 nrlc280_1 nrlc280_2 1
Crlc280 nrlc280_2 rlc12 5.0914586413e-05
* RLC[284] rlc10-GND
Rrlc284 rlc10 nrlc284_1 2.17374825455
Lrlc284 nrlc284_1 nrlc284_2 1
Crlc284 nrlc284_2 GND 0.000235146759375
* RLC[286] rlc11-rlc13
Rrlc286 rlc11 nrlc286_1 1.19244410533
Lrlc286 nrlc286_1 nrlc286_2 2.64820531418e-07
Crlc286 nrlc286_2 rlc13 3.85373551318e-10
* RLC[288] rlc11-rlc15
Rrlc288 rlc11 nrlc288_1 102.342707594
Lrlc288 nrlc288_1 nrlc288_2 0.551303673403
Crlc288 nrlc288_2 rlc15 5.84836637801e-08
* RLC[289] rlc11-GND
Rrlc289 rlc11 nrlc289_1 152.102169877
Lrlc289 nrlc289_1 nrlc289_2 1
Crlc289 nrlc289_2 GND 4.80271340092e-08
* RLC[293] rlc12-GND
Rrlc293 rlc12 nrlc293_1 127.26082205
Lrlc293 nrlc293_1 nrlc293_2 0.000244368302375
Crlc293 nrlc293_2 GND 1.67653611745e-11
* RLC[294] rlc13-rlc14
Rrlc294 rlc13 nrlc294_1 0.664403520711
Lrlc294 nrlc294_1 nrlc294_2 0.0432262868219
Crlc294 nrlc294_2 rlc14 0.000108803175595
* RLC[295] rlc13-rlc15
Rrlc295 rlc13 nrlc295_1 0.0468352036346
Lrlc295 nrlc295_1 nrlc295_2 9.48064182623e-11
Crlc295 nrlc295_2 rlc15 9.33928774075e-11
* RLC[296] rlc13-GND
Rrlc296 rlc13 nrlc296_1 2.09598230051
Lrlc296 nrlc296_1 nrlc296_2 1
Crlc296 nrlc296_2 GND 0.000252919473276
* RLC[297] rlc14-rlc15
Rrlc297 rlc14 nrlc297_1 68.3929158002
Lrlc297 nrlc297_1 nrlc297_2 1
Crlc297 nrlc297_2 rlc15 2.37539179322e-07
* DC[0] P1A-P2A
Rdc0 P1A ndc0_1 0.085906407978
Ldc0 ndc0_1 P2A 1.55343964466e-07
* DC[1] P1A-P3A
Rdc1 P1A ndc1_1 8.12216401816e+13
Ldc1 ndc1_1 P3A 1
* DC[4] P1A-P2B
Rdc4 P1A ndc4_1 3.35250411304e+13
Ldc4 ndc4_1 P2B 1
* DC[16] P2A-P3B
Rdc16 P2A ndc16_1 3.4133790851e+13
Ldc16 ndc16_1 P3B 1
* DC[17] P2A-P4B
Rdc17 P2A ndc17_1 1.09062479213e+13
Ldc17 ndc17_1 P4B 1
* DC[23] P3A-P4A
Rdc23 P3A ndc23_1 0.129900878994
Ldc23 ndc23_1 P4A 1.83248058924e-07
* DC[24] P3A-P1B
Rdc24 P3A ndc24_1 3.22519812215e+13
Ldc24 ndc24_1 P1B 1
* DC[27] P3A-P4B
Rdc27 P3A ndc27_1 1.56997509587e+13
Ldc27 ndc27_1 P4B 1
* DC[28] P3A-dc0
Rdc28 P3A ndc28_1 3.11200359854e+13
Ldc28 ndc28_1 dc0 1
* DC[29] P3A-dc1
Rdc29 P3A ndc29_1 3.13435179968e+13
Ldc29 ndc29_1 dc1 1
* DC[31] P3A-dc3
Rdc31 P3A ndc31_1 3.25198590088e+13
Ldc31 ndc31_1 dc3 1
* DC[35] P4A-P3B
Rdc35 P4A ndc35_1 3.01663203482e+13
Ldc35 ndc35_1 P3B 1
* DC[36] P4A-P4B
Rdc36 P4A ndc36_1 2.89224131251e+13
Ldc36 ndc36_1 P4B 1
* DC[43] P1B-P3B
Rdc43 P1B ndc43_1 0.000618377062655
Ldc43 ndc43_1 P3B 3.82575475448e-09
* DC[46] P1B-dc1
Rdc46 P1B ndc46_1 0.0001
Ldc46 ndc46_1 dc1 8.49321432012e-08
* DC[50] P2B-P3B
Rdc50 P2B ndc50_1 0.00499909999547
Ldc50 ndc50_1 P3B 9.55298056832e-07
* DC[51] P2B-P4B
Rdc51 P2B ndc51_1 0.000749758863792
Ldc51 ndc51_1 P4B 3.76812811104e-09
* DC[52] P2B-dc0
Rdc52 P2B ndc52_1 0.0298188368554
Ldc52 ndc52_1 dc0 4.74581528279e-09
* DC[55] P2B-dc3
Rdc55 P2B ndc55_1 0.00810451598103
Ldc55 ndc55_1 dc3 1.28987377975e-09
* DC[57] P3B-P4B
Rdc57 P3B ndc57_1 0.00339091844672
Ldc57 ndc57_1 P4B 9.76957182349e-08
* DC[63] P4B-dc0
Rdc63 P4B ndc63_1 0.00449830175577
Ldc63 ndc63_1 dc0 4.51169711763e-08
* DC[68] dc0-dc1
Rdc68 dc0 ndc68_1 0.0001
Ldc68 ndc68_1 dc1 7.16636568116e-08
* DC[70] dc0-dc3
Rdc70 dc0 ndc70_1 0.0001
Ldc70 ndc70_1 dc3 2.22562270497e-07
* DC[73] dc1-dc3
Rdc73 dc1 ndc73_1 0.0937676510714
Ldc73 ndc73_1 dc3 1.49235851701e-08
* ---- leaks
Rleak_P1A P1A GND 1e+12
Rleak_P1B P1B GND 1e+12
Rleak_P2A P2A GND 1e+12
Rleak_P2B P2B GND 1e+12
Rleak_P3A P3A GND 1e+12
Rleak_P3B P3B GND 1e+12
Rleak_P4A P4A GND 1e+12
Rleak_P4B P4B GND 1e+12
Rleak_dc0 dc0 GND 1e+12
Rleak_dc1 dc1 GND 1e+12
Rleak_dc3 dc3 GND 1e+12
Rleak_rlc0 rlc0 GND 1e+12
Rleak_rlc1 rlc1 GND 1e+12
Rleak_rlc10 rlc10 GND 1e+12
Rleak_rlc11 rlc11 GND 1e+12
Rleak_rlc12 rlc12 GND 1e+12
Rleak_rlc13 rlc13 GND 1e+12
Rleak_rlc14 rlc14 GND 1e+12
Rleak_rlc15 rlc15 GND 1e+12
Rleak_rlc2 rlc2 GND 1e+12
Rleak_rlc3 rlc3 GND 1e+12
Rleak_rlc4 rlc4 GND 1e+12
Rleak_rlc5 rlc5 GND 1e+12
Rleak_rlc6 rlc6 GND 1e+12
Rleak_rlc7 rlc7 GND 1e+12
Rleak_rlc8 rlc8 GND 1e+12
Rleak_rlc9 rlc9 GND 1e+12
.ends fitted
