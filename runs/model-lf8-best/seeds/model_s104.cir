* fitted: 8-port fitted model, reference z0 = 50 Ohm
* every pin is a port against GND
.subckt fitted P1A P1B P2A P2B P3A P3B P4A P4B GND
* ---- branches
* RLC[1] P1A-P3A
Rrlc1 P1A nrlc1_1 1e+15
Lrlc1 nrlc1_1 nrlc1_2 0.991494225802
Crlc1 nrlc1_2 P3A 1.97616863568e-06
* RLC[2] P1A-P4A
Rrlc2 P1A nrlc2_1 2696.32905431
Lrlc2 nrlc2_1 nrlc2_2 0.000335575245741
Crlc2 nrlc2_2 P4A 5.12863302371e-14
* RLC[3] P1A-P1B
Rrlc3 P1A nrlc3_1 286042348098
Lrlc3 nrlc3_1 nrlc3_2 0.998130513865
Crlc3 nrlc3_2 P1B 0.000376570640253
* RLC[4] P1A-P2B
Rrlc4 P1A nrlc4_1 1.10433429737e+12
Lrlc4 nrlc4_1 nrlc4_2 0.00594286675192
Crlc4 nrlc4_2 P2B 4.17846216412e-10
* RLC[5] P1A-P3B
Rrlc5 P1A nrlc5_1 2.5845647792e+12
Lrlc5 nrlc5_1 nrlc5_2 0.999990559547
Crlc5 nrlc5_2 P3B 1.98412302141e-11
* RLC[6] P1A-P4B
Rrlc6 P1A nrlc6_1 1333317.93289
Lrlc6 nrlc6_1 nrlc6_2 0.00110424624303
Crlc6 nrlc6_2 P4B 3.91951160246e-13
* RLC[8] P1A-rlc1
Rrlc8 P1A nrlc8_1 9522.99995542
Lrlc8 nrlc8_1 nrlc8_2 1.41636488377e-08
Crlc8 nrlc8_2 rlc1 1.32751396353e-14
* RLC[9] P1A-rlc2
Rrlc9 P1A nrlc9_1 713697.251068
Lrlc9 nrlc9_1 nrlc9_2 1
Crlc9 nrlc9_2 rlc2 2.18137053493e-15
* RLC[24] P2A-P3A
Rrlc24 P2A nrlc24_1 3.50918664775e+12
Lrlc24 nrlc24_1 nrlc24_2 0.826310003014
Crlc24 nrlc24_2 P3A 1.21614218501e-17
* RLC[25] P2A-P4A
Rrlc25 P2A nrlc25_1 1e+15
Lrlc25 nrlc25_1 nrlc25_2 0.019875207521
Crlc25 nrlc25_2 P4A 9.80608585654e-09
* RLC[26] P2A-P1B
Rrlc26 P2A nrlc26_1 10946.3503824
Lrlc26 nrlc26_1 nrlc26_2 5.52706234551e-05
Crlc26 nrlc26_2 P1B 1.17067644847e-12
* RLC[27] P2A-P2B
Rrlc27 P2A nrlc27_1 542550045630
Lrlc27 nrlc27_1 nrlc27_2 0.999890852291
Crlc27 nrlc27_2 P2B 2.00586197705e-09
* RLC[28] P2A-P3B
Rrlc28 P2A nrlc28_1 5.30953401747
Lrlc28 nrlc28_1 nrlc28_2 2.68545161627e-07
Crlc28 nrlc28_2 P3B 1.05842967466e-11
* RLC[29] P2A-P4B
Rrlc29 P2A nrlc29_1 256832706436
Lrlc29 nrlc29_1 nrlc29_2 0.999887834454
Crlc29 nrlc29_2 P4B 3.95730299067e-07
* RLC[30] P2A-rlc0
Rrlc30 P2A nrlc30_1 6474273.54428
Lrlc30 nrlc30_1 nrlc30_2 1
Crlc30 nrlc30_2 rlc0 2.65079047225e-17
* RLC[35] P2A-rlc5
Rrlc35 P2A nrlc35_1 2830429.50606
Lrlc35 nrlc35_1 nrlc35_2 1
Crlc35 nrlc35_2 rlc5 1.38692445104e-16
* RLC[47] P3A-P4A
Rrlc47 P3A nrlc47_1 30.9977720174
Lrlc47 nrlc47_1 nrlc47_2 0.00298094490995
Crlc47 nrlc47_2 P4A 0.001
* RLC[48] P3A-P1B
Rrlc48 P3A nrlc48_1 137924144169
Lrlc48 nrlc48_1 nrlc48_2 0.335461711252
Crlc48 nrlc48_2 P1B 0.000999999580082
* RLC[49] P3A-P2B
Rrlc49 P3A nrlc49_1 521149.293392
Lrlc49 nrlc49_1 nrlc49_2 0.0138287912151
Crlc49 nrlc49_2 P2B 7.9630279836e-13
* RLC[50] P3A-P3B
Rrlc50 P3A nrlc50_1 4.96187068778
Lrlc50 nrlc50_1 nrlc50_2 2.53746317262e-07
Crlc50 nrlc50_2 P3B 1.14516048735e-11
* RLC[51] P3A-P4B
Rrlc51 P3A nrlc51_1 145120835552
Lrlc51 nrlc51_1 nrlc51_2 0.000716307447277
Crlc51 nrlc51_2 P4B 1.83021183623e-07
* RLC[59] P3A-rlc7
Rrlc59 P3A nrlc59_1 136090.930856
Lrlc59 nrlc59_1 nrlc59_2 2.33948928245e-06
Crlc59 nrlc59_2 rlc7 4.91529305513e-15
* RLC[69] P4A-P1B
Rrlc69 P4A nrlc69_1 987539108667
Lrlc69 nrlc69_1 nrlc69_2 0.949949072004
Crlc69 nrlc69_2 P1B 8.71543928345e-09
* RLC[70] P4A-P2B
Rrlc70 P4A nrlc70_1 1820.34251726
Lrlc70 nrlc70_1 nrlc70_2 6.50523232828e-06
Crlc70 nrlc70_2 P2B 6.56723654781e-12
* RLC[71] P4A-P3B
Rrlc71 P4A nrlc71_1 962001862350
Lrlc71 nrlc71_1 nrlc71_2 0.771236844542
Crlc71 nrlc71_2 P3B 1.58307424925e-06
* RLC[72] P4A-P4B
Rrlc72 P4A nrlc72_1 148254296027
Lrlc72 nrlc72_1 nrlc72_2 0.860910997279
Crlc72 nrlc72_2 P4B 1.26721807492e-05
* RLC[76] P4A-rlc3
Rrlc76 P4A nrlc76_1 713338.292578
Lrlc76 nrlc76_1 nrlc76_2 1
Crlc76 nrlc76_2 rlc3 2.18356645934e-15
* RLC[77] P4A-rlc4
Rrlc77 P4A nrlc77_1 152400.271486
Lrlc77 nrlc77_1 nrlc77_2 0.0662406486293
Crlc77 nrlc77_2 rlc4 3.1689149666e-15
* RLC[78] P4A-rlc5
Rrlc78 P4A nrlc78_1 33781.7729211
Lrlc78 nrlc78_1 nrlc78_2 4.39159048355e-11
Crlc78 nrlc78_2 rlc5 6.74681690219e-16
* RLC[83] P4A-rlc10
Rrlc83 P4A nrlc83_1 273639.819024
Lrlc83 nrlc83_1 nrlc83_2 0.0112672352381
Crlc83 nrlc83_2 rlc10 1.67192296503e-16
* RLC[85] P4A-rlc12
Rrlc85 P4A nrlc85_1 2842341.35406
Lrlc85 nrlc85_1 nrlc85_2 1.07734742032e-08
Crlc85 nrlc85_2 rlc12 1.26396558405e-14
* RLC[92] P1B-P4B
Rrlc92 P1B nrlc92_1 210.106467723
Lrlc92 nrlc92_1 nrlc92_2 1
Crlc92 nrlc92_2 P4B 2.51697352552e-08
* RLC[103] P1B-rlc10
Rrlc103 P1B nrlc103_1 545.974438117
Lrlc103 nrlc103_1 nrlc103_2 1.34432435092e-06
Crlc103 nrlc103_2 rlc10 7.42839619547e-13
* RLC[111] P2B-P4B
Rrlc111 P2B nrlc111_1 11531135.2562
Lrlc111 nrlc111_1 nrlc111_2 2.21977108031e-07
Crlc111 nrlc111_2 P4B 3.65899140087e-09
* RLC[115] P2B-rlc3
Rrlc115 P2B nrlc115_1 14.9202285457
Lrlc115 nrlc115_1 nrlc115_2 5.93118770995e-07
Crlc115 nrlc115_2 rlc3 2.96038508893e-12
* RLC[122] P2B-rlc10
Rrlc122 P2B nrlc122_1 84206.2492077
Lrlc122 nrlc122_1 nrlc122_2 0.0297253602761
Crlc122 nrlc122_2 rlc10 4.65796232513e-15
* RLC[129] P3B-P4B
Rrlc129 P3B nrlc129_1 43.988515624
Lrlc129 nrlc129_1 nrlc129_2 0.00677164265598
Crlc129 nrlc129_2 P4B 0.001
* RLC[135] P3B-rlc5
Rrlc135 P3B nrlc135_1 5527.38949874
Lrlc135 nrlc135_1 nrlc135_2 8.20747610929e-08
Crlc135 nrlc135_2 rlc5 2.27396795218e-14
* RLC[140] P3B-rlc10
Rrlc140 P3B nrlc140_1 29.7483657673
Lrlc140 nrlc140_1 nrlc140_2 1.16787605062e-06
Crlc140 nrlc140_2 rlc10 1.46631750008e-12
* RLC[152] P4B-rlc5
Rrlc152 P4B nrlc152_1 1472220.28559
Lrlc152 nrlc152_1 nrlc152_2 0.820891906574
Crlc152 nrlc152_2 rlc5 4.20821450842e-16
* RLC[154] P4B-rlc7
Rrlc154 P4B nrlc154_1 1102.91075825
Lrlc154 nrlc154_1 nrlc154_2 1.97938332003e-12
Crlc154 nrlc154_2 rlc7 5.28555247547e-13
* RLC[169] rlc0-rlc6
Rrlc169 rlc0 nrlc169_1 0.722999263816
Lrlc169 nrlc169_1 nrlc169_2 0.00799832871914
Crlc169 nrlc169_2 rlc6 1.70012568814e-05
* RLC[177] rlc0-rlc14
Rrlc177 rlc0 nrlc177_1 137.389976733
Lrlc177 nrlc177_1 nrlc177_2 0.00014107115033
Crlc177 nrlc177_2 rlc14 8.30396668787e-12
* RLC[179] rlc0-GND
Rrlc179 rlc0 nrlc179_1 20.3280655004
Lrlc179 nrlc179_1 nrlc179_2 0.0128982404382
Crlc179 nrlc179_2 GND 3.4681338961e-08
* RLC[183] rlc1-rlc5
Rrlc183 rlc1 nrlc183_1 26522.6292352
Lrlc183 nrlc183_1 nrlc183_2 0.00344179469583
Crlc183 nrlc183_2 rlc5 5.43637370299e-15
* RLC[185] rlc1-rlc7
Rrlc185 rlc1 nrlc185_1 57008.1018796
Lrlc185 nrlc185_1 nrlc185_2 8.80854188579e-06
Crlc185 nrlc185_2 rlc7 2.90479004241e-14
* RLC[186] rlc1-rlc8
Rrlc186 rlc1 nrlc186_1 0.0823454031172
Lrlc186 nrlc186_1 nrlc186_2 0.0053220060071
Crlc186 nrlc186_2 rlc8 0.000872114319672
* RLC[187] rlc1-rlc9
Rrlc187 rlc1 nrlc187_1 1.05583809522
Lrlc187 nrlc187_1 nrlc187_2 1
Crlc187 nrlc187_2 rlc9 0.00099669627578
* RLC[190] rlc1-rlc12
Rrlc190 rlc1 nrlc190_1 0.0176658640228
Lrlc190 nrlc190_1 nrlc190_2 1.4572013378e-08
Crlc190 nrlc190_2 rlc12 6.1704345412e-08
* RLC[191] rlc1-rlc13
Rrlc191 rlc1 nrlc191_1 3458.59946854
Lrlc191 nrlc191_1 nrlc191_2 7.59924151635e-11
Crlc191 nrlc191_2 rlc13 7.98457250884e-14
* RLC[195] rlc2-rlc3
Rrlc195 rlc2 nrlc195_1 0.198821608998
Lrlc195 nrlc195_1 nrlc195_2 4.02261976956e-08
Crlc195 nrlc195_2 rlc3 1.13067894774e-09
* RLC[198] rlc2-rlc6
Rrlc198 rlc2 nrlc198_1 884.906742416
Lrlc198 nrlc198_1 nrlc198_2 0.00354330098144
Crlc198 nrlc198_2 rlc6 5.02771355734e-12
* RLC[209] rlc3-rlc4
Rrlc209 rlc3 nrlc209_1 439.154555018
Lrlc209 nrlc209_1 nrlc209_2 0.940214735122
Crlc209 nrlc209_2 rlc4 5.4168868045e-09
* RLC[210] rlc3-rlc5
Rrlc210 rlc3 nrlc210_1 6689.55827036
Lrlc210 nrlc210_1 nrlc210_2 1
Crlc210 nrlc210_2 rlc5 2.48291932341e-11
* RLC[211] rlc3-rlc6
Rrlc211 rlc3 nrlc211_1 210972279.505
Lrlc211 nrlc211_1 nrlc211_2 0.941215682476
Crlc211 nrlc211_2 rlc6 0.001
* RLC[213] rlc3-rlc8
Rrlc213 rlc3 nrlc213_1 69.6094936883
Lrlc213 nrlc213_1 nrlc213_2 6.47198588024e-05
Crlc213 nrlc213_2 rlc8 1.48589391073e-11
* RLC[215] rlc3-rlc10
Rrlc215 rlc3 nrlc215_1 0.0619481236475
Lrlc215 nrlc215_1 nrlc215_2 2.9507689304e-09
Crlc215 nrlc215_2 rlc10 8.54352578811e-10
* RLC[221] rlc3-GND
Rrlc221 rlc3 nrlc221_1 0.00196981992169
Lrlc221 nrlc221_1 nrlc221_2 6.27223001889e-13
Crlc221 nrlc221_2 GND 1.79608305894e-10
* RLC[231] rlc4-rlc14
Rrlc231 rlc4 nrlc231_1 0.107778285927
Lrlc231 nrlc231_1 nrlc231_2 0.010399870448
Crlc231 nrlc231_2 rlc14 0.00099477044787
* RLC[232] rlc4-rlc15
Rrlc232 rlc4 nrlc232_1 348.005260515
Lrlc232 nrlc232_1 nrlc232_2 0.000289523882564
Crlc232 nrlc232_2 rlc15 2.65625807049e-12
* RLC[234] rlc5-rlc6
Rrlc234 rlc5 nrlc234_1 369.151994451
Lrlc234 nrlc234_1 nrlc234_2 0.0290388248377
Crlc234 nrlc234_2 rlc6 2.36769681147e-10
* RLC[235] rlc5-rlc7
Rrlc235 rlc5 nrlc235_1 4.86689725972
Lrlc235 nrlc235_1 nrlc235_2 0.406265475408
Crlc235 nrlc235_2 rlc7 0.00020489985194
* RLC[236] rlc5-rlc8
Rrlc236 rlc5 nrlc236_1 46.1079851623
Lrlc236 nrlc236_1 nrlc236_2 8.1016167032e-08
Crlc236 nrlc236_2 rlc8 4.29713831397e-14
* RLC[241] rlc5-rlc13
Rrlc241 rlc5 nrlc241_1 7.65847687076
Lrlc241 nrlc241_1 nrlc241_2 0.31890001172
Crlc241 nrlc241_2 rlc13 6.04125566768e-06
* RLC[245] rlc6-rlc7
Rrlc245 rlc6 nrlc245_1 0.0608108620222
Lrlc245 nrlc245_1 nrlc245_2 0.00249494668301
Crlc245 nrlc245_2 rlc7 0.000749646366251
* RLC[247] rlc6-rlc9
Rrlc247 rlc6 nrlc247_1 1.11216749826
Lrlc247 nrlc247_1 nrlc247_2 1
Crlc247 nrlc247_2 rlc9 0.000916780712058
* RLC[249] rlc6-rlc11
Rrlc249 rlc6 nrlc249_1 1.05409264338
Lrlc249 nrlc249_1 nrlc249_2 1
Crlc249 nrlc249_2 rlc11 0.00099999982925
* RLC[254] rlc6-GND
Rrlc254 rlc6 nrlc254_1 0.0934995482822
Lrlc254 nrlc254_1 nrlc254_2 0.00404830747508
Crlc254 nrlc254_2 GND 0.000514531485574
* RLC[260] rlc7-rlc13
Rrlc260 rlc7 nrlc260_1 0.00417843286064
Lrlc260 nrlc260_1 nrlc260_2 1.26511699444e-06
Crlc260 nrlc260_2 rlc13 8.06851255393e-05
* RLC[273] rlc9-rlc11
Rrlc273 rlc9 nrlc273_1 0.19394837177
Lrlc273 nrlc273_1 nrlc273_2 6.60860024864e-06
Crlc273 nrlc273_2 rlc11 1.95206689794e-07
* RLC[281] rlc10-rlc13
Rrlc281 rlc10 nrlc281_1 5596.0515808
Lrlc281 nrlc281_1 nrlc281_2 8.76972369003e-05
Crlc281 nrlc281_2 rlc13 1.66066739883e-10
* RLC[282] rlc10-rlc14
Rrlc282 rlc10 nrlc282_1 253.215618328
Lrlc282 nrlc282_1 nrlc282_2 0.00146497893792
Crlc282 nrlc282_2 rlc14 2.53867959631e-11
* RLC[286] rlc11-rlc13
Rrlc286 rlc11 nrlc286_1 1.07921125456
Lrlc286 nrlc286_1 nrlc286_2 1
Crlc286 nrlc286_2 rlc13 0.000953991618439
* RLC[289] rlc11-GND
Rrlc289 rlc11 nrlc289_1 1.05415318764
Lrlc289 nrlc289_1 nrlc289_2 1
Crlc289 nrlc289_2 GND 0.000999884964527
* RLC[296] rlc13-GND
Rrlc296 rlc13 nrlc296_1 0.0111130998402
Lrlc296 nrlc296_1 nrlc296_2 2.98251339483e-08
Crlc296 nrlc296_2 GND 2.68348549607e-07
* RLC[299] rlc15-GND
Rrlc299 rlc15 nrlc299_1 0.355478643076
Lrlc299 nrlc299_1 nrlc299_2 0.00411267813979
Crlc299 nrlc299_2 GND 3.61622284834e-05
* DC[0] P1A-P2A
Rdc0 P1A ndc0_1 0.0859086267106
Ldc0 ndc0_1 P2A 1.058447612e-07
* DC[1] P1A-P3A
Rdc1 P1A ndc1_1 1e+15
Ldc1 ndc1_1 P3A 1
* DC[3] P1A-P1B
Rdc3 P1A ndc3_1 4.40100407871e+12
Ldc3 ndc3_1 P1B 1
* DC[4] P1A-P2B
Rdc4 P1A ndc4_1 3.98666019832e+12
Ldc4 ndc4_1 P2B 1
* DC[5] P1A-P3B
Rdc5 P1A ndc5_1 4.42590075178e+12
Ldc5 ndc5_1 P3B 1
* DC[7] P1A-dc0
Rdc7 P1A ndc7_1 4.42827818504e+12
Ldc7 ndc7_1 dc0 1
* DC[8] P1A-dc1
Rdc8 P1A ndc8_1 4.42741433672e+12
Ldc8 ndc8_1 dc1 1
* DC[9] P1A-dc2
Rdc9 P1A ndc9_1 4.42687045535e+12
Ldc9 ndc9_1 dc2 1
* DC[10] P1A-dc3
Rdc10 P1A ndc10_1 4.42323002735e+12
Ldc10 ndc10_1 dc3 1
* DC[13] P2A-P4A
Rdc13 P2A ndc13_1 1e+15
Ldc13 ndc13_1 P4A 1
* DC[15] P2A-P2B
Rdc15 P2A ndc15_1 4.41999097005e+12
Ldc15 ndc15_1 P2B 1
* DC[17] P2A-P4B
Rdc17 P2A ndc17_1 4.42381321724e+12
Ldc17 ndc17_1 P4B 1
* DC[19] P2A-dc1
Rdc19 P2A ndc19_1 4.32654478672e+12
Ldc19 ndc19_1 dc1 1
* DC[20] P2A-dc2
Rdc20 P2A ndc20_1 4.4045070362e+12
Ldc20 ndc20_1 dc2 1
* DC[21] P2A-dc3
Rdc21 P2A ndc21_1 4.39615854926e+12
Ldc21 ndc21_1 dc3 1
* DC[23] P3A-P4A
Rdc23 P3A ndc23_1 0.130428261411
Ldc23 ndc23_1 P4A 1.56740427853e-07
* DC[43] P1B-P3B
Rdc43 P1B ndc43_1 0.00106059845339
Ldc43 ndc43_1 P3B 8.05890638996e-09
* DC[45] P1B-dc0
Rdc45 P1B ndc45_1 0.0268551219088
Ldc45 ndc45_1 dc0 4.27412539912e-09
* DC[46] P1B-dc1
Rdc46 P1B ndc46_1 26219.9435007
Ldc46 ndc46_1 dc1 0.73824792145
* DC[47] P1B-dc2
Rdc47 P1B ndc47_1 21644.4393085
Ldc47 ndc47_1 dc2 1
* DC[48] P1B-dc3
Rdc48 P1B ndc48_1 0.000668146206247
Ldc48 ndc48_1 dc3 7.23320833508e-09
* DC[50] P2B-P3B
Rdc50 P2B ndc50_1 22013.5431018
Ldc50 ndc50_1 P3B 1
* DC[51] P2B-P4B
Rdc51 P2B ndc51_1 0.000821024326548
Ldc51 ndc51_1 P4B 3.8148124587e-09
* DC[52] P2B-dc0
Rdc52 P2B ndc52_1 0.0496653737611
Ldc52 ndc52_1 dc0 9.59444906253e-08
* DC[54] P2B-dc2
Rdc54 P2B ndc54_1 0.00187548198083
Ldc54 ndc54_1 dc2 2.90389797129e-08
* DC[57] P3B-P4B
Rdc57 P3B ndc57_1 0.0872783109295
Ldc57 ndc57_1 P4B 1.30115942031e-07
* DC[58] P3B-dc0
Rdc58 P3B ndc58_1 0.015806190191
Ldc58 ndc58_1 dc0 7.16023341492e-07
* DC[59] P3B-dc1
Rdc59 P3B ndc59_1 0.00503878162125
Ldc59 ndc59_1 dc1 8.01947002182e-10
* DC[60] P3B-dc2
Rdc60 P3B ndc60_1 388551.927988
Ldc60 ndc60_1 dc2 1
* DC[61] P3B-dc3
Rdc61 P3B ndc61_1 0.000559055592175
Ldc61 ndc61_1 dc3 8.89764609577e-11
* DC[64] P4B-dc1
Rdc64 P4B ndc64_1 0.0221220543136
Ldc64 ndc64_1 dc1 1.76250175678e-06
* DC[65] P4B-dc2
Rdc65 P4B ndc65_1 0.00134060580431
Ldc65 ndc65_1 dc2 2.13364040493e-10
* DC[66] P4B-dc3
Rdc66 P4B ndc66_1 321813.17669
Ldc66 ndc66_1 dc3 1
* DC[72] dc1-dc2
Rdc72 dc1 ndc72_1 0.0001
Ldc72 ndc72_1 dc2 3.84946918686e-08
* DC[73] dc1-dc3
Rdc73 dc1 ndc73_1 0.000100000586854
Ldc73 ndc73_1 dc3 7.11145245104e-09
* ---- leaks
Rleak_P1A P1A GND 1e+12
Rleak_P1B P1B GND 1e+12
Rleak_P2A P2A GND 1e+12
Rleak_P2B P2B GND 1e+12
Rleak_P3A P3A GND 1e+12
Rleak_P3B P3B GND 1e+12
Rleak_P4A P4A GND 1e+12
Rleak_P4B P4B GND 1e+12
Rleak_dc0 dc0 GND 1e+12
Rleak_dc1 dc1 GND 1e+12
Rleak_dc2 dc2 GND 1e+12
Rleak_dc3 dc3 GND 1e+12
Rleak_rlc0 rlc0 GND 1e+12
Rleak_rlc1 rlc1 GND 1e+12
Rleak_rlc10 rlc10 GND 1e+12
Rleak_rlc11 rlc11 GND 1e+12
Rleak_rlc12 rlc12 GND 1e+12
Rleak_rlc13 rlc13 GND 1e+12
Rleak_rlc14 rlc14 GND 1e+12
Rleak_rlc15 rlc15 GND 1e+12
Rleak_rlc2 rlc2 GND 1e+12
Rleak_rlc3 rlc3 GND 1e+12
Rleak_rlc4 rlc4 GND 1e+12
Rleak_rlc5 rlc5 GND 1e+12
Rleak_rlc6 rlc6 GND 1e+12
Rleak_rlc7 rlc7 GND 1e+12
Rleak_rlc8 rlc8 GND 1e+12
Rleak_rlc9 rlc9 GND 1e+12
.ends fitted
