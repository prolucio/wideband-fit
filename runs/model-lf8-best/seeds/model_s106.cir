* fitted: 8-port fitted model, reference z0 = 50 Ohm
* every pin is a port against GND
.subckt fitted P1A P1B P2A P2B P3A P3B P4A P4B GND
* ---- branches
* RLC[1] P1A-P3A
Rrlc1 P1A nrlc1_1 24089.2438839
Lrlc1 nrlc1_1 nrlc1_2 7.68551267863e-05
Crlc1 nrlc1_2 P3A 1.27527071794e-14
* RLC[2] P1A-P4A
Rrlc2 P1A nrlc2_1 8457795.54823
Lrlc2 nrlc2_1 nrlc2_2 1
Crlc2 nrlc2_2 P4A 1.5532563052e-17
* RLC[3] P1A-P1B
Rrlc3 P1A nrlc3_1 4769386.18625
Lrlc3 nrlc3_1 nrlc3_2 1
Crlc3 nrlc3_2 P1B 4.88463943762e-17
* RLC[4] P1A-P2B
Rrlc4 P1A nrlc4_1 1.03695468093e+12
Lrlc4 nrlc4_1 nrlc4_2 0.342352998303
Crlc4 nrlc4_2 P2B 3.72785913898e-06
* RLC[5] P1A-P3B
Rrlc5 P1A nrlc5_1 8.1621827311e+12
Lrlc5 nrlc5_1 nrlc5_2 0.969175842004
Crlc5 nrlc5_2 P3B 1.47298802795e-08
* RLC[6] P1A-P4B
Rrlc6 P1A nrlc6_1 6.00499305185e+12
Lrlc6 nrlc6_1 nrlc6_2 0.975445007
Crlc6 nrlc6_2 P4B 2.66960401929e-07
* RLC[7] P1A-rlc0
Rrlc7 P1A nrlc7_1 2210506.53724
Lrlc7 nrlc7_1 nrlc7_2 1
Crlc7 nrlc7_2 rlc0 2.27391320318e-16
* RLC[19] P1A-rlc12
Rrlc19 P1A nrlc19_1 195021.70574
Lrlc19 nrlc19_1 nrlc19_2 3.77910077231e-10
Crlc19 nrlc19_2 rlc12 5.08472622441e-17
* RLC[22] P1A-rlc15
Rrlc22 P1A nrlc22_1 75507.9691279
Lrlc22 nrlc22_1 nrlc22_2 0.0165256141488
Crlc22 nrlc22_2 rlc15 3.2205460967e-15
* RLC[24] P2A-P3A
Rrlc24 P2A nrlc24_1 1e+15
Lrlc24 nrlc24_1 nrlc24_2 0.996513214697
Crlc24 nrlc24_2 P3A 2.01116641167e-06
* RLC[25] P2A-P4A
Rrlc25 P2A nrlc25_1 7.02920767732e+14
Lrlc25 nrlc25_1 nrlc25_2 0.999997740393
Crlc25 nrlc25_2 P4A 2.33430486975e-09
* RLC[26] P2A-P1B
Rrlc26 P2A nrlc26_1 3.74674418173e+13
Lrlc26 nrlc26_1 nrlc26_2 0.963224643315
Crlc26 nrlc26_2 P1B 1.09695944328e-09
* RLC[27] P2A-P2B
Rrlc27 P2A nrlc27_1 17.9270533618
Lrlc27 nrlc27_1 nrlc27_2 1.16138984464e-06
Crlc27 nrlc27_2 P2B 4.01529716645e-12
* RLC[28] P2A-P3B
Rrlc28 P2A nrlc28_1 1.23256223001e+13
Lrlc28 nrlc28_1 nrlc28_2 0.160449152924
Crlc28 nrlc28_2 P3B 0.00030811311666
* RLC[29] P2A-P4B
Rrlc29 P2A nrlc29_1 2.78945254876e+12
Lrlc29 nrlc29_1 nrlc29_2 0.858079733182
Crlc29 nrlc29_2 P4B 6.12498165201e-06
* RLC[32] P2A-rlc2
Rrlc32 P2A nrlc32_1 88824.6151439
Lrlc32 nrlc32_1 nrlc32_2 1
Crlc32 nrlc32_2 rlc2 1.40828586934e-13
* RLC[34] P2A-rlc4
Rrlc34 P2A nrlc34_1 626255.393502
Lrlc34 nrlc34_1 nrlc34_2 1
Crlc34 nrlc34_2 rlc4 2.83305191037e-15
* RLC[36] P2A-rlc6
Rrlc36 P2A nrlc36_1 39758.6792777
Lrlc36 nrlc36_1 nrlc36_2 0.00191602003688
Crlc36 nrlc36_2 rlc6 1.34677063434e-15
* RLC[38] P2A-rlc8
Rrlc38 P2A nrlc38_1 1631122.25962
Lrlc38 nrlc38_1 nrlc38_2 0.239924388839
Crlc38 nrlc38_2 rlc8 1.00197955211e-16
* RLC[43] P2A-rlc13
Rrlc43 P2A nrlc43_1 96809.1326698
Lrlc43 nrlc43_1 nrlc43_2 1
Crlc43 nrlc43_2 rlc13 1.18556353255e-13
* RLC[44] P2A-rlc14
Rrlc44 P2A nrlc44_1 40400.3571401
Lrlc44 nrlc44_1 nrlc44_2 1
Crlc44 nrlc44_2 rlc14 6.80749109584e-13
* RLC[47] P3A-P4A
Rrlc47 P3A nrlc47_1 3.85260181105
Lrlc47 nrlc47_1 nrlc47_2 8.16087899824e-07
Crlc47 nrlc47_2 P4A 4.31131589833e-07
* RLC[48] P3A-P1B
Rrlc48 P3A nrlc48_1 54273091041.5
Lrlc48 nrlc48_1 nrlc48_2 0.866305839245
Crlc48 nrlc48_2 P1B 2.14595206509e-06
* RLC[49] P3A-P2B
Rrlc49 P3A nrlc49_1 9.16925080027
Lrlc49 nrlc49_1 nrlc49_2 5.27896210513e-07
Crlc49 nrlc49_2 P2B 6.97651177058e-12
* RLC[50] P3A-P3B
Rrlc50 P3A nrlc50_1 37310.5653185
Lrlc50 nrlc50_1 nrlc50_2 1
Crlc50 nrlc50_2 P3B 7.98167117161e-13
* RLC[51] P3A-P4B
Rrlc51 P3A nrlc51_1 596166334421
Lrlc51 nrlc51_1 nrlc51_2 0.487792861163
Crlc51 nrlc51_2 P4B 1.27758282846e-08
* RLC[53] P3A-rlc1
Rrlc53 P3A nrlc53_1 7471.7052603
Lrlc53 nrlc53_1 nrlc53_2 1
Crlc53 nrlc53_2 rlc1 1.9902976355e-11
* RLC[55] P3A-rlc3
Rrlc55 P3A nrlc55_1 947.988244461
Lrlc55 nrlc55_1 nrlc55_2 2.8335764529e-05
Crlc55 nrlc55_2 rlc3 3.50337415375e-14
* RLC[58] P3A-rlc6
Rrlc58 P3A nrlc58_1 39368.5050719
Lrlc58 nrlc58_1 nrlc58_2 0.322866429529
Crlc58 nrlc58_2 rlc6 2.31463509672e-13
* RLC[59] P3A-rlc7
Rrlc59 P3A nrlc59_1 329065.150964
Lrlc59 nrlc59_1 nrlc59_2 1
Crlc59 nrlc59_2 rlc7 1.02610949755e-14
* RLC[61] P3A-rlc9
Rrlc61 P3A nrlc61_1 939.632079678
Lrlc61 nrlc61_1 nrlc61_2 1
Crlc61 nrlc61_2 rlc9 1.25846696473e-09
* RLC[65] P3A-rlc13
Rrlc65 P3A nrlc65_1 106936.510181
Lrlc65 nrlc65_1 nrlc65_2 1.10106633518e-09
Crlc65 nrlc65_2 rlc13 2.77465833381e-12
* RLC[66] P3A-rlc14
Rrlc66 P3A nrlc66_1 32645.557115
Lrlc66 nrlc66_1 nrlc66_2 1
Crlc66 nrlc66_2 rlc14 1.04257983692e-12
* RLC[69] P4A-P1B
Rrlc69 P4A nrlc69_1 8.56083715475
Lrlc69 nrlc69_1 nrlc69_2 4.97492508761e-07
Crlc69 nrlc69_2 P1B 7.54243479295e-12
* RLC[70] P4A-P2B
Rrlc70 P4A nrlc70_1 1635311.35723
Lrlc70 nrlc70_1 nrlc70_2 0.199436194177
Crlc70 nrlc70_2 P2B 8.28629828434e-17
* RLC[71] P4A-P3B
Rrlc71 P4A nrlc71_1 64370262161.8
Lrlc71 nrlc71_1 nrlc71_2 0.769554120405
Crlc71 nrlc71_2 P3B 1.46797129392e-06
* RLC[72] P4A-P4B
Rrlc72 P4A nrlc72_1 15991299064
Lrlc72 nrlc72_1 nrlc72_2 0.958745806859
Crlc72 nrlc72_2 P4B 9.97834792278e-06
* RLC[76] P4A-rlc3
Rrlc76 P4A nrlc76_1 14246.1302411
Lrlc76 nrlc76_1 nrlc76_2 1
Crlc76 nrlc76_2 rlc3 5.47474215176e-12
* RLC[79] P4A-rlc6
Rrlc79 P4A nrlc79_1 46848.3987687
Lrlc79 nrlc79_1 nrlc79_2 1
Crlc79 nrlc79_2 rlc6 5.06253439807e-13
* RLC[80] P4A-rlc7
Rrlc80 P4A nrlc80_1 4.46491132987
Lrlc80 nrlc80_1 nrlc80_2 6.30597310395e-09
Crlc80 nrlc80_2 rlc7 3.51466492734e-13
* RLC[81] P4A-rlc8
Rrlc81 P4A nrlc81_1 4599999.82656
Lrlc81 nrlc81_1 nrlc81_2 1
Crlc81 nrlc81_2 rlc8 5.25099808554e-17
* RLC[85] P4A-rlc12
Rrlc85 P4A nrlc85_1 774.688023451
Lrlc85 nrlc85_1 nrlc85_2 1
Crlc85 nrlc85_2 rlc12 1.85141512253e-09
* RLC[92] P1B-P4B
Rrlc92 P1B nrlc92_1 4.78018302518
Lrlc92 nrlc92_1 nrlc92_2 1.5487448532e-07
Crlc92 nrlc92_2 P4B 1.55819460206e-11
* RLC[93] P1B-rlc0
Rrlc93 P1B nrlc93_1 13653.5412017
Lrlc93 nrlc93_1 nrlc93_2 1
Crlc93 nrlc93_2 rlc0 5.96028298874e-12
* RLC[97] P1B-rlc4
Rrlc97 P1B nrlc97_1 0.651538839262
Lrlc97 nrlc97_1 nrlc97_2 1.80397179407e-09
Crlc97 nrlc97_2 rlc4 4.72178941015e-12
* RLC[105] P1B-rlc12
Rrlc105 P1B nrlc105_1 1.35530237811
Lrlc105 nrlc105_1 nrlc105_2 2.5111148804e-09
Crlc105 nrlc105_2 rlc12 1.51897865608e-12
* RLC[107] P1B-rlc14
Rrlc107 P1B nrlc107_1 21938.8920243
Lrlc107 nrlc107_1 nrlc107_2 1
Crlc107 nrlc107_2 rlc14 2.308490593e-12
* RLC[113] P2B-rlc1
Rrlc113 P2B nrlc113_1 27645.7782525
Lrlc113 nrlc113_1 nrlc113_2 0.00981563354738
Crlc113 nrlc113_2 rlc1 1.4269809862e-14
* RLC[115] P2B-rlc3
Rrlc115 P2B nrlc115_1 38154.2854461
Lrlc115 nrlc115_1 nrlc115_2 0.249432884757
Crlc115 nrlc115_2 rlc3 1.90381415299e-13
* RLC[123] P2B-rlc11
Rrlc123 P2B nrlc123_1 48.9083534868
Lrlc123 nrlc123_1 nrlc123_2 1.31166455831e-07
Crlc123 nrlc123_2 rlc11 6.09276166172e-14
* RLC[124] P2B-rlc12
Rrlc124 P2B nrlc124_1 20582.4137535
Lrlc124 nrlc124_1 nrlc124_2 1
Crlc124 nrlc124_2 rlc12 2.62279823076e-12
* RLC[134] P3B-rlc4
Rrlc134 P3B nrlc134_1 29607.7805355
Lrlc134 nrlc134_1 nrlc134_2 1
Crlc134 nrlc134_2 rlc4 1.26749362794e-12
* RLC[135] P3B-rlc5
Rrlc135 P3B nrlc135_1 9717.9191634
Lrlc135 nrlc135_1 nrlc135_2 1
Crlc135 nrlc135_2 rlc5 1.17655145774e-11
* RLC[137] P3B-rlc7
Rrlc137 P3B nrlc137_1 481899.324478
Lrlc137 nrlc137_1 nrlc137_2 1
Crlc137 nrlc137_2 rlc7 4.78459140238e-15
* RLC[142] P3B-rlc12
Rrlc142 P3B nrlc142_1 47601.6831156
Lrlc142 nrlc142_1 nrlc142_2 0.0214678455585
Crlc142 nrlc142_2 rlc12 1.05269203031e-14
* RLC[143] P3B-rlc13
Rrlc143 P3B nrlc143_1 9298.62278035
Lrlc143 nrlc143_1 nrlc143_2 1
Crlc143 nrlc143_2 rlc13 1.28505060582e-11
* RLC[147] P4B-rlc0
Rrlc147 P4B nrlc147_1 20582.4841246
Lrlc147 nrlc147_1 nrlc147_2 1
Crlc147 nrlc147_2 rlc0 2.62278029618e-12
* RLC[152] P4B-rlc5
Rrlc152 P4B nrlc152_1 26974.0194343
Lrlc152 nrlc152_1 nrlc152_2 4.53552314762e-05
Crlc152 nrlc152_2 rlc5 6.15935156043e-15
* RLC[153] P4B-rlc6
Rrlc153 P4B nrlc153_1 20552.2723182
Lrlc153 nrlc153_1 nrlc153_2 1
Crlc153 nrlc153_2 rlc6 2.63049692917e-12
* RLC[154] P4B-rlc7
Rrlc154 P4B nrlc154_1 25036.6608479
Lrlc154 nrlc154_1 nrlc154_2 1
Crlc154 nrlc154_2 rlc7 1.77257523709e-12
* RLC[155] P4B-rlc8
Rrlc155 P4B nrlc155_1 25056.9255788
Lrlc155 nrlc155_1 nrlc155_2 1
Crlc155 nrlc155_2 rlc8 1.7697092642e-12
* RLC[156] P4B-rlc9
Rrlc156 P4B nrlc156_1 84228.0022895
Lrlc156 nrlc156_1 nrlc156_2 0.428069760884
Crlc156 nrlc156_2 rlc9 6.70438645684e-14
* RLC[157] P4B-rlc10
Rrlc157 P4B nrlc157_1 20491.1758669
Lrlc157 nrlc157_1 nrlc157_2 1
Crlc157 nrlc157_2 rlc10 2.64620648344e-12
* RLC[162] P4B-rlc15
Rrlc162 P4B nrlc162_1 20932.1925624
Lrlc162 nrlc162_1 nrlc162_2 0.00585861127456
Crlc162 nrlc162_2 rlc15 1.48567129036e-14
* RLC[164] rlc0-rlc1
Rrlc164 rlc0 nrlc164_1 6.12666610427
Lrlc164 nrlc164_1 nrlc164_2 1
Crlc164 nrlc164_2 rlc1 2.96011828509e-05
* RLC[165] rlc0-rlc2
Rrlc165 rlc0 nrlc165_1 2.19130980882
Lrlc165 nrlc165_1 nrlc165_2 1
Crlc165 nrlc165_2 rlc2 0.000231392844609
* RLC[166] rlc0-rlc3
Rrlc166 rlc0 nrlc166_1 0.609929033157
Lrlc166 nrlc166_1 nrlc166_2 0.123523755152
Crlc166 nrlc166_2 rlc3 0.000368934579864
* RLC[167] rlc0-rlc4
Rrlc167 rlc0 nrlc167_1 112.807144789
Lrlc167 nrlc167_1 nrlc167_2 1
Crlc167 nrlc167_2 rlc4 8.73140787846e-08
* RLC[168] rlc0-rlc5
Rrlc168 rlc0 nrlc168_1 399.663130904
Lrlc168 nrlc168_1 nrlc168_2 1
Crlc168 nrlc168_2 rlc5 6.95615608082e-09
* RLC[169] rlc0-rlc6
Rrlc169 rlc0 nrlc169_1 27.2070845613
Lrlc169 nrlc169_1 nrlc169_2 0.000163994553036
Crlc169 nrlc169_2 rlc6 2.4616307094e-10
* RLC[170] rlc0-rlc7
Rrlc170 rlc0 nrlc170_1 174.016404342
Lrlc170 nrlc170_1 nrlc170_2 1
Crlc170 nrlc170_2 rlc7 3.66924836325e-08
* RLC[171] rlc0-rlc8
Rrlc171 rlc0 nrlc171_1 90481.5280388
Lrlc171 nrlc171_1 nrlc171_2 1
Crlc171 nrlc171_2 rlc8 1.35718058417e-13
* RLC[172] rlc0-rlc9
Rrlc172 rlc0 nrlc172_1 15.0046525825
Lrlc172 nrlc172_1 nrlc172_2 1
Crlc172 nrlc172_2 rlc9 4.93520960082e-06
* RLC[173] rlc0-rlc10
Rrlc173 rlc0 nrlc173_1 4.8364448693
Lrlc173 nrlc173_1 nrlc173_2 1
Crlc173 nrlc173_2 rlc10 4.75012466165e-05
* RLC[174] rlc0-rlc11
Rrlc174 rlc0 nrlc174_1 0.748721099128
Lrlc174 nrlc174_1 nrlc174_2 0.260020266867
Crlc174 nrlc174_2 rlc11 0.000515376422615
* RLC[175] rlc0-rlc12
Rrlc175 rlc0 nrlc175_1 0.334314475194
Lrlc175 nrlc175_1 nrlc175_2 2.46586537121e-05
Crlc175 nrlc175_2 rlc12 2.45141302913e-07
* RLC[179] rlc0-GND
Rrlc179 rlc0 nrlc179_1 1.85389282711
Lrlc179 nrlc179_1 nrlc179_2 1
Crlc179 nrlc179_2 GND 0.000323287000875
* RLC[180] rlc1-rlc2
Rrlc180 rlc1 nrlc180_1 79.5512890829
Lrlc180 nrlc180_1 nrlc180_2 1
Crlc180 nrlc180_2 rlc2 1.75575149747e-07
* RLC[182] rlc1-rlc4
Rrlc182 rlc1 nrlc182_1 41.33116888
Lrlc182 nrlc182_1 nrlc182_2 1
Crlc182 nrlc182_2 rlc4 6.50432322998e-07
* RLC[183] rlc1-rlc5
Rrlc183 rlc1 nrlc183_1 32.0848278086
Lrlc183 nrlc183_1 nrlc183_2 1
Crlc183 nrlc183_2 rlc5 1.07933948461e-06
* RLC[186] rlc1-rlc8
Rrlc186 rlc1 nrlc186_1 2147.75668159
Lrlc186 nrlc186_1 nrlc186_2 1
Crlc186 nrlc186_2 rlc8 2.40872562574e-10
* RLC[189] rlc1-rlc11
Rrlc189 rlc1 nrlc189_1 1299.08047335
Lrlc189 nrlc189_1 nrlc189_2 1
Crlc189 nrlc189_2 rlc11 6.58393266756e-10
* RLC[191] rlc1-rlc13
Rrlc191 rlc1 nrlc191_1 4.52406173684
Lrlc191 nrlc191_1 nrlc191_2 7.73272817101e-08
Crlc191 nrlc191_2 rlc13 4.19791063012e-12
* RLC[193] rlc1-rlc15
Rrlc193 rlc1 nrlc193_1 234.355656308
Lrlc193 nrlc193_1 nrlc193_2 0.0105360980511
Crlc193 nrlc193_2 rlc15 2.13150528747e-10
* RLC[194] rlc1-GND
Rrlc194 rlc1 nrlc194_1 523.279352623
Lrlc194 nrlc194_1 nrlc194_2 0.0018736573637
Crlc194 nrlc194_2 GND 7.60292081215e-12
* RLC[195] rlc2-rlc3
Rrlc195 rlc2 nrlc195_1 2.42422872281
Lrlc195 nrlc195_1 nrlc195_2 1
Crlc195 nrlc195_2 rlc3 0.00018906463712
* RLC[196] rlc2-rlc4
Rrlc196 rlc2 nrlc196_1 378489.865486
Lrlc196 nrlc196_1 nrlc196_2 1
Crlc196 nrlc196_2 rlc4 7.75619965858e-15
* RLC[197] rlc2-rlc5
Rrlc197 rlc2 nrlc197_1 18.3366958549
Lrlc197 nrlc197_1 nrlc197_2 0.0469833776309
Crlc197 nrlc197_2 rlc5 1.55259993069e-07
* RLC[198] rlc2-rlc6
Rrlc198 rlc2 nrlc198_1 1.45561908628
Lrlc198 nrlc198_1 nrlc198_2 1
Crlc198 nrlc198_2 rlc6 0.000524399184451
* RLC[200] rlc2-rlc8
Rrlc200 rlc2 nrlc200_1 10.9580750263
Lrlc200 nrlc200_1 nrlc200_2 0.151144957564
Crlc200 nrlc200_2 rlc8 1.39856486753e-06
* RLC[201] rlc2-rlc9
Rrlc201 rlc2 nrlc201_1 86.38985019
Lrlc201 nrlc201_1 nrlc201_2 1
Crlc201 nrlc201_2 rlc9 1.48878522042e-07
* RLC[202] rlc2-rlc10
Rrlc202 rlc2 nrlc202_1 3.56493158916
Lrlc202 nrlc202_1 nrlc202_2 0.364363594299
Crlc202 nrlc202_2 rlc10 3.18559138184e-05
* RLC[203] rlc2-rlc11
Rrlc203 rlc2 nrlc203_1 21830.4395735
Lrlc203 nrlc203_1 nrlc203_2 1
Crlc203 nrlc203_2 rlc11 2.33148448212e-12
* RLC[204] rlc2-rlc12
Rrlc204 rlc2 nrlc204_1 57.2946130369
Lrlc204 nrlc204_1 nrlc204_2 1
Crlc204 nrlc204_2 rlc12 3.38477581651e-07
* RLC[205] rlc2-rlc13
Rrlc205 rlc2 nrlc205_1 881.764685269
Lrlc205 nrlc205_1 nrlc205_2 1
Crlc205 nrlc205_2 rlc13 1.42906534587e-09
* RLC[206] rlc2-rlc14
Rrlc206 rlc2 nrlc206_1 3.2384765264
Lrlc206 nrlc206_1 nrlc206_2 1
Crlc206 nrlc206_2 rlc14 0.000105943906703
* RLC[208] rlc2-GND
Rrlc208 rlc2 nrlc208_1 120.265123286
Lrlc208 nrlc208_1 nrlc208_2 1
Crlc208 nrlc208_2 GND 7.68206697044e-08
* RLC[209] rlc3-rlc4
Rrlc209 rlc3 nrlc209_1 119.813354283
Lrlc209 nrlc209_1 nrlc209_2 1
Crlc209 nrlc209_2 rlc4 7.74010829207e-08
* RLC[213] rlc3-rlc8
Rrlc213 rlc3 nrlc213_1 419.088038408
Lrlc213 nrlc213_1 nrlc213_2 1
Crlc213 nrlc213_2 rlc8 6.32625887769e-09
* RLC[216] rlc3-rlc11
Rrlc216 rlc3 nrlc216_1 1.29352574703
Lrlc216 nrlc216_1 nrlc216_2 0.364641023558
Crlc216 nrlc216_2 rlc11 0.000242143526106
* RLC[219] rlc3-rlc14
Rrlc219 rlc3 nrlc219_1 609122.181285
Lrlc219 nrlc219_1 nrlc219_2 0.0747089165914
Crlc219 nrlc219_2 rlc14 2.23728391154e-16
* RLC[221] rlc3-GND
Rrlc221 rlc3 nrlc221_1 386.537158417
Lrlc221 nrlc221_1 nrlc221_2 0.000968465962905
Crlc221 nrlc221_2 GND 7.20210341502e-12
* RLC[222] rlc4-rlc5
Rrlc222 rlc4 nrlc222_1 20.0588819479
Lrlc222 nrlc222_1 nrlc222_2 1
Crlc222 nrlc222_2 rlc5 2.76149362955e-06
* RLC[223] rlc4-rlc6
Rrlc223 rlc4 nrlc223_1 108.831908077
Lrlc223 nrlc223_1 nrlc223_2 1
Crlc223 nrlc223_2 rlc6 9.38091074121e-08
* RLC[224] rlc4-rlc7
Rrlc224 rlc4 nrlc224_1 1.54914120041
Lrlc224 nrlc224_1 nrlc224_2 1
Crlc224 nrlc224_2 rlc7 0.000462994126553
* RLC[225] rlc4-rlc8
Rrlc225 rlc4 nrlc225_1 1.23883667787
Lrlc225 nrlc225_1 nrlc225_2 1
Crlc225 nrlc225_2 rlc8 0.00072398468737
* RLC[226] rlc4-rlc9
Rrlc226 rlc4 nrlc226_1 4.0777277784
Lrlc226 nrlc226_1 nrlc226_2 5.97403779955e-07
Crlc226 nrlc226_2 rlc9 3.99198588782e-11
* RLC[227] rlc4-rlc10
Rrlc227 rlc4 nrlc227_1 63.6540130305
Lrlc227 nrlc227_1 nrlc227_2 0.000121259172415
Crlc227 nrlc227_2 rlc10 3.32522098835e-11
* RLC[229] rlc4-rlc12
Rrlc229 rlc4 nrlc229_1 155.850618877
Lrlc229 nrlc229_1 nrlc229_2 1
Crlc229 nrlc229_2 rlc12 4.57446625458e-08
* RLC[231] rlc4-rlc14
Rrlc231 rlc4 nrlc231_1 118.644297143
Lrlc231 nrlc231_1 nrlc231_2 1
Crlc231 nrlc231_2 rlc14 7.89339351935e-08
* RLC[232] rlc4-rlc15
Rrlc232 rlc4 nrlc232_1 2.99732813164
Lrlc232 nrlc232_1 nrlc232_2 1.75865357031e-05
Crlc232 nrlc232_2 rlc15 2.17504981989e-09
* RLC[233] rlc4-GND
Rrlc233 rlc4 nrlc233_1 108.166353014
Lrlc233 nrlc233_1 nrlc233_2 1
Crlc233 nrlc233_2 GND 9.49670869221e-08
* RLC[235] rlc5-rlc7
Rrlc235 rlc5 nrlc235_1 0.349029995316
Lrlc235 nrlc235_1 nrlc235_2 5.77869879727e-07
Crlc235 nrlc235_2 rlc7 5.27062413086e-09
* RLC[236] rlc5-rlc8
Rrlc236 rlc5 nrlc236_1 15.2403197432
Lrlc236 nrlc236_1 nrlc236_2 0.0062186565343
Crlc236 nrlc236_2 rlc8 2.97485569717e-08
* RLC[237] rlc5-rlc9
Rrlc237 rlc5 nrlc237_1 1.27703203115
Lrlc237 nrlc237_1 nrlc237_2 1
Crlc237 nrlc237_2 rlc9 0.000681324348153
* RLC[239] rlc5-rlc11
Rrlc239 rlc5 nrlc239_1 3.02790831161
Lrlc239 nrlc239_1 nrlc239_2 1
Crlc239 nrlc239_2 rlc11 0.00012119146917
* RLC[240] rlc5-rlc12
Rrlc240 rlc5 nrlc240_1 83.6832015292
Lrlc240 nrlc240_1 nrlc240_2 1
Crlc240 nrlc240_2 rlc12 1.58664919836e-07
* RLC[241] rlc5-rlc13
Rrlc241 rlc5 nrlc241_1 3.03971924488
Lrlc241 nrlc241_1 nrlc241_2 1
Crlc241 nrlc241_2 rlc13 0.000120251511632
* RLC[242] rlc5-rlc14
Rrlc242 rlc5 nrlc242_1 206.655558971
Lrlc242 nrlc242_1 nrlc242_2 1
Crlc242 nrlc242_2 rlc14 2.60173647893e-08
* RLC[243] rlc5-rlc15
Rrlc243 rlc5 nrlc243_1 34.6980730612
Lrlc243 nrlc243_1 nrlc243_2 1
Crlc243 nrlc243_2 rlc15 9.22883276541e-07
* RLC[244] rlc5-GND
Rrlc244 rlc5 nrlc244_1 124.507435277
Lrlc244 nrlc244_1 nrlc244_2 1
Crlc244 nrlc244_2 GND 7.16748703694e-08
* RLC[246] rlc6-rlc8
Rrlc246 rlc6 nrlc246_1 9582.23016706
Lrlc246 nrlc246_1 nrlc246_2 1
Crlc246 nrlc246_2 rlc8 1.21010845007e-11
* RLC[247] rlc6-rlc9
Rrlc247 rlc6 nrlc247_1 0.731320774976
Lrlc247 nrlc247_1 nrlc247_2 8.59972885934e-11
Crlc247 nrlc247_2 rlc9 1.7865962889e-13
* RLC[249] rlc6-rlc11
Rrlc249 rlc6 nrlc249_1 0.546642330009
Lrlc249 nrlc249_1 nrlc249_2 0.147751728813
Crlc249 nrlc249_2 rlc11 0.000549393534341
* RLC[254] rlc6-GND
Rrlc254 rlc6 nrlc254_1 1.42475744629
Lrlc254 nrlc254_1 nrlc254_2 1
Crlc254 nrlc254_2 GND 0.000547363230091
* RLC[255] rlc7-rlc8
Rrlc255 rlc7 nrlc255_1 1776.80589761
Lrlc255 nrlc255_1 nrlc255_2 0.622161568073
Crlc255 nrlc255_2 rlc8 2.18968022849e-10
* RLC[256] rlc7-rlc9
Rrlc256 rlc7 nrlc256_1 4.51029711425
Lrlc256 nrlc256_1 nrlc256_2 1
Crlc256 nrlc256_2 rlc9 5.46194329339e-05
* RLC[258] rlc7-rlc11
Rrlc258 rlc7 nrlc258_1 348.170059108
Lrlc258 nrlc258_1 nrlc258_2 1
Crlc258 nrlc258_2 rlc11 9.16589015086e-09
* RLC[261] rlc7-rlc14
Rrlc261 rlc7 nrlc261_1 4.13386203218
Lrlc261 nrlc261_1 nrlc261_2 1
Crlc261 nrlc261_2 rlc14 6.50197858384e-05
* RLC[262] rlc7-rlc15
Rrlc262 rlc7 nrlc262_1 4.91768029513
Lrlc262 nrlc262_1 nrlc262_2 1
Crlc262 nrlc262_2 rlc15 4.59448574102e-05
* RLC[263] rlc7-GND
Rrlc263 rlc7 nrlc263_1 1.68790191012
Lrlc263 nrlc263_1 nrlc263_2 1
Crlc263 nrlc263_2 GND 0.000389998629848
* RLC[264] rlc8-rlc9
Rrlc264 rlc8 nrlc264_1 107.288495342
Lrlc264 nrlc264_1 nrlc264_2 1
Crlc264 nrlc264_2 rlc9 9.65275273279e-08
* RLC[265] rlc8-rlc10
Rrlc265 rlc8 nrlc265_1 8.32368765023
Lrlc265 nrlc265_1 nrlc265_2 1
Crlc265 nrlc265_2 rlc10 1.60371038312e-05
* RLC[266] rlc8-rlc11
Rrlc266 rlc8 nrlc266_1 2343.66330598
Lrlc266 nrlc266_1 nrlc266_2 1
Crlc266 nrlc266_2 rlc11 2.02286569599e-10
* RLC[267] rlc8-rlc12
Rrlc267 rlc8 nrlc267_1 2359.3377348
Lrlc267 nrlc267_1 nrlc267_2 1
Crlc267 nrlc267_2 rlc12 1.99607687372e-10
* RLC[268] rlc8-rlc13
Rrlc268 rlc8 nrlc268_1 1793.55745322
Lrlc268 nrlc268_1 nrlc268_2 1
Crlc268 nrlc268_2 rlc13 3.45403635597e-10
* RLC[270] rlc8-rlc15
Rrlc270 rlc8 nrlc270_1 1.66733531304
Lrlc270 nrlc270_1 nrlc270_2 1
Crlc270 nrlc270_2 rlc15 0.00039967924278
* RLC[271] rlc8-GND
Rrlc271 rlc8 nrlc271_1 158.212333517
Lrlc271 nrlc271_1 nrlc271_2 1
Crlc271 nrlc271_2 GND 4.43891489225e-08
* RLC[273] rlc9-rlc11
Rrlc273 rlc9 nrlc273_1 9.67425552732
Lrlc273 nrlc273_1 nrlc273_2 1
Crlc273 nrlc273_2 rlc11 1.18719588335e-05
* RLC[274] rlc9-rlc12
Rrlc274 rlc9 nrlc274_1 2017.84916808
Lrlc274 nrlc274_1 nrlc274_2 0.000244718142705
Crlc274 nrlc274_2 rlc12 6.67799759423e-14
* RLC[276] rlc9-rlc14
Rrlc276 rlc9 nrlc276_1 165.592817319
Lrlc276 nrlc276_1 nrlc276_2 1
Crlc276 nrlc276_2 rlc14 4.05204724489e-08
* RLC[278] rlc9-GND
Rrlc278 rlc9 nrlc278_1 0.00019559795182
Lrlc278 nrlc278_1 nrlc278_2 7.04018890108e-14
Crlc278 nrlc278_2 GND 2.04462278942e-09
* RLC[279] rlc10-rlc11
Rrlc279 rlc10 nrlc279_1 4.32397762968
Lrlc279 nrlc279_1 nrlc279_2 0.615334585212
Crlc279 nrlc279_2 rlc11 3.65680615445e-05
* RLC[280] rlc10-rlc12
Rrlc280 rlc10 nrlc280_1 51.321777851
Lrlc280 nrlc280_1 nrlc280_2 6.43090153767e-05
Crlc280 nrlc280_2 rlc12 2.71285115319e-11
* RLC[282] rlc10-rlc14
Rrlc282 rlc10 nrlc282_1 243.092898878
Lrlc282 nrlc282_1 nrlc282_2 1
Crlc282 nrlc282_2 rlc14 1.88023851833e-08
* RLC[286] rlc11-rlc13
Rrlc286 rlc11 nrlc286_1 3.78704948123
Lrlc286 nrlc286_1 nrlc286_2 1
Crlc286 nrlc286_2 rlc13 7.74739200947e-05
* RLC[287] rlc11-rlc14
Rrlc287 rlc11 nrlc287_1 0.506371014827
Lrlc287 nrlc287_1 nrlc287_2 0.229970357032
Crlc287 nrlc287_2 rlc14 0.000996532973872
* RLC[289] rlc11-GND
Rrlc289 rlc11 nrlc289_1 1.70743138309
Lrlc289 nrlc289_1 nrlc289_2 1
Crlc289 nrlc289_2 GND 0.000381128101312
* RLC[290] rlc12-rlc13
Rrlc290 rlc12 nrlc290_1 506.045685113
Lrlc290 nrlc290_1 nrlc290_2 1
Crlc290 nrlc290_2 rlc13 4.3388839889e-09
* RLC[291] rlc12-rlc14
Rrlc291 rlc12 nrlc291_1 0.000181496922422
Lrlc291 nrlc291_1 nrlc291_2 4.2748197644e-13
Crlc291 nrlc291_2 rlc14 1.44190540138e-08
* RLC[294] rlc13-rlc14
Rrlc294 rlc13 nrlc294_1 0.237297330646
Lrlc294 nrlc294_1 nrlc294_2 1.12794848514e-09
Crlc294 nrlc294_2 rlc14 2.22567142562e-11
* RLC[295] rlc13-rlc15
Rrlc295 rlc13 nrlc295_1 0.012118968779
Lrlc295 nrlc295_1 nrlc295_2 2.39506697877e-08
Crlc295 nrlc295_2 rlc15 1.81194003289e-07
* RLC[296] rlc13-GND
Rrlc296 rlc13 nrlc296_1 9.66886764434
Lrlc296 nrlc296_1 nrlc296_2 1.92356801714e-06
Crlc296 nrlc296_2 GND 2.28619782642e-11
* RLC[297] rlc14-rlc15
Rrlc297 rlc14 nrlc297_1 178.424022934
Lrlc297 nrlc297_1 nrlc297_2 1
Crlc297 nrlc297_2 rlc15 3.4902041949e-08
* RLC[299] rlc15-GND
Rrlc299 rlc15 nrlc299_1 1.47705167041
Lrlc299 nrlc299_1 nrlc299_2 1
Crlc299 nrlc299_2 GND 0.000509291132234
* DC[0] P1A-P2A
Rdc0 P1A ndc0_1 0.0859086266145
Ldc0 ndc0_1 P2A 1.05751397413e-07
* DC[2] P1A-P4A
Rdc2 P1A ndc2_1 1e+15
Ldc2 ndc2_1 P4A 1
* DC[3] P1A-P1B
Rdc3 P1A ndc3_1 1.74710417075e+12
Ldc3 ndc3_1 P1B 1
* DC[4] P1A-P2B
Rdc4 P1A ndc4_1 1.74769133385e+12
Ldc4 ndc4_1 P2B 1
* DC[5] P1A-P3B
Rdc5 P1A ndc5_1 2.29068504548e+12
Ldc5 ndc5_1 P3B 1
* DC[6] P1A-P4B
Rdc6 P1A ndc6_1 1.79197196929e+12
Ldc6 ndc6_1 P4B 1
* DC[7] P1A-dc0
Rdc7 P1A ndc7_1 1.77487983826e+12
Ldc7 ndc7_1 dc0 1
* DC[8] P1A-dc1
Rdc8 P1A ndc8_1 1.82611461333e+12
Ldc8 ndc8_1 dc1 1
* DC[9] P1A-dc2
Rdc9 P1A ndc9_1 1.81045103874e+12
Ldc9 ndc9_1 dc2 1
* DC[10] P1A-dc3
Rdc10 P1A ndc10_1 1.95131703931e+12
Ldc10 ndc10_1 dc3 1
* DC[12] P2A-P3A
Rdc12 P2A ndc12_1 1e+15
Ldc12 ndc12_1 P3A 1
* DC[13] P2A-P4A
Rdc13 P2A ndc13_1 1e+15
Ldc13 ndc13_1 P4A 1
* DC[14] P2A-P1B
Rdc14 P2A ndc14_1 2.68208245807e+13
Ldc14 ndc14_1 P1B 1
* DC[16] P2A-P3B
Rdc16 P2A ndc16_1 1.99427835123e+12
Ldc16 ndc16_1 P3B 1
* DC[17] P2A-P4B
Rdc17 P2A ndc17_1 1.97262452892e+12
Ldc17 ndc17_1 P4B 1
* DC[18] P2A-dc0
Rdc18 P2A ndc18_1 2.84729830816e+12
Ldc18 ndc18_1 dc0 1
* DC[19] P2A-dc1
Rdc19 P2A ndc19_1 1.82649305843e+12
Ldc19 ndc19_1 dc1 1
* DC[21] P2A-dc3
Rdc21 P2A ndc21_1 1.74776593725e+12
Ldc21 ndc21_1 dc3 1
* DC[23] P3A-P4A
Rdc23 P3A ndc23_1 0.129900910498
Ldc23 ndc23_1 P4A 1.83386066816e-07
* DC[24] P3A-P1B
Rdc24 P3A ndc24_1 5.51667350354e+12
Ldc24 ndc24_1 P1B 1
* DC[27] P3A-P4B
Rdc27 P3A ndc27_1 1.00981362822e+13
Ldc27 ndc27_1 P4B 1
* DC[29] P3A-dc1
Rdc29 P3A ndc29_1 5.85723147236e+12
Ldc29 ndc29_1 dc1 1
* DC[30] P3A-dc2
Rdc30 P3A ndc30_1 9.14257167105e+12
Ldc30 ndc30_1 dc2 1
* DC[31] P3A-dc3
Rdc31 P3A ndc31_1 6.25552059102e+12
Ldc31 ndc31_1 dc3 1
* DC[34] P4A-P2B
Rdc34 P4A ndc34_1 9.41758416596e+12
Ldc34 ndc34_1 P2B 1
* DC[35] P4A-P3B
Rdc35 P4A ndc35_1 1.00241857285e+13
Ldc35 ndc35_1 P3B 1
* DC[36] P4A-P4B
Rdc36 P4A ndc36_1 5.88519824319e+12
Ldc36 ndc36_1 P4B 1
* DC[38] P4A-dc1
Rdc38 P4A ndc38_1 4.0794192901e+12
Ldc38 ndc38_1 dc1 1
* DC[40] P4A-dc3
Rdc40 P4A ndc40_1 8.84113377166e+12
Ldc40 ndc40_1 dc3 1
* DC[42] P1B-P2B
Rdc42 P1B ndc42_1 0.084796140162
Ldc42 ndc42_1 P2B 1.00578551594e-07
* DC[43] P1B-P3B
Rdc43 P1B ndc43_1 0.00122883201911
Ldc43 ndc43_1 P3B 8.88145003496e-09
* DC[47] P1B-dc2
Rdc47 P1B ndc47_1 0.000491494779304
Ldc47 ndc47_1 dc2 6.5873635565e-09
* DC[51] P2B-P4B
Rdc51 P2B ndc51_1 0.000852305449238
Ldc51 ndc51_1 P4B 3.95424026177e-09
* DC[53] P2B-dc1
Rdc53 P2B ndc53_1 0.00159923171639
Ldc53 ndc53_1 dc1 2.28337956069e-08
* DC[57] P3B-P4B
Rdc57 P3B ndc57_1 0.189114018084
Ldc57 ndc57_1 P4B 1.43547597618e-05
* DC[59] P3B-dc1
Rdc59 P3B ndc59_1 0.0351317014266
Ldc59 ndc59_1 dc1 3.65748975425e-06
* DC[60] P3B-dc2
Rdc60 P3B ndc60_1 0.000664379345002
Ldc60 ndc60_1 dc2 1.05739256845e-10
* DC[61] P3B-dc3
Rdc61 P3B ndc61_1 0.00176624687113
Ldc61 ndc61_1 dc3 2.81106920261e-10
* DC[63] P4B-dc0
Rdc63 P4B ndc63_1 0.0361413362798
Ldc63 ndc63_1 dc0 9.14375468205e-08
* DC[64] P4B-dc1
Rdc64 P4B ndc64_1 0.00124685741971
Ldc64 ndc64_1 dc1 1.98443521677e-10
* DC[65] P4B-dc2
Rdc65 P4B ndc65_1 0.017912661962
Ldc65 ndc65_1 dc2 1.05158328024e-06
* DC[68] dc0-dc1
Rdc68 dc0 ndc68_1 0.0055011469123
Ldc68 ndc68_1 dc1 4.79145560789e-07
* DC[69] dc0-dc2
Rdc69 dc0 ndc69_1 0.0001
Ldc69 ndc69_1 dc2 6.85501155921e-08
* DC[70] dc0-dc3
Rdc70 dc0 ndc70_1 0.0148826196903
Ldc70 ndc70_1 dc3 2.36864248987e-09
* DC[73] dc1-dc3
Rdc73 dc1 ndc73_1 0.0001
Ldc73 ndc73_1 dc3 4.98802346934e-08
* DC[75] dc2-dc3
Rdc75 dc2 ndc75_1 0.000510461906621
Ldc75 ndc75_1 dc3 6.64637098523e-09
* ---- leaks
Rleak_P1A P1A GND 1e+12
Rleak_P1B P1B GND 1e+12
Rleak_P2A P2A GND 1e+12
Rleak_P2B P2B GND 1e+12
Rleak_P3A P3A GND 1e+12
Rleak_P3B P3B GND 1e+12
Rleak_P4A P4A GND 1e+12
Rleak_P4B P4B GND 1e+12
Rleak_dc0 dc0 GND 1e+12
Rleak_dc1 dc1 GND 1e+12
Rleak_dc2 dc2 GND 1e+12
Rleak_dc3 dc3 GND 1e+12
Rleak_rlc0 rlc0 GND 1e+12
Rleak_rlc1 rlc1 GND 1e+12
Rleak_rlc10 rlc10 GND 1e+12
Rleak_rlc11 rlc11 GND 1e+12
Rleak_rlc12 rlc12 GND 1e+12
Rleak_rlc13 rlc13 GND 1e+12
Rleak_rlc14 rlc14 GND 1e+12
Rleak_rlc15 rlc15 GND 1e+12
Rleak_rlc2 rlc2 GND 1e+12
Rleak_rlc3 rlc3 GND 1e+12
Rleak_rlc4 rlc4 GND 1e+12
Rleak_rlc5 rlc5 GND 1e+12
Rleak_rlc6 rlc6 GND 1e+12
Rleak_rlc7 rlc7 GND 1e+12
Rleak_rlc8 rlc8 GND 1e+12
Rleak_rlc9 rlc9 GND 1e+12
.ends fitted
