* fitted: 8-port fitted model, reference z0 = 50 Ohm
* every pin is a port against GND
.subckt fitted P1A P1B P2A P2B P3A P3B P4A P4B GND
* ---- branches
* RLC[0] P1A-P2A
Rrlc0 P1A nrlc0_1 16.7256535333
Lrlc0 nrlc0_1 nrlc0_2 0.00227711996379
Crlc0 nrlc0_2 P2A 0.001
* RLC[1] P1A-P3A
Rrlc1 P1A nrlc1_1 1e+15
Lrlc1 nrlc1_1 nrlc1_2 0.170559686881
Crlc1 nrlc1_2 P3A 1.70402503376e-08
* RLC[2] P1A-P4A
Rrlc2 P1A nrlc2_1 1e+15
Lrlc2 nrlc2_1 nrlc2_2 0.000338224309138
Crlc2 nrlc2_2 P4A 7.72483811681e-10
* RLC[3] P1A-P1B
Rrlc3 P1A nrlc3_1 1507761.6757
Lrlc3 nrlc3_1 nrlc3_2 1
Crlc3 nrlc3_2 P1B 4.88755986797e-16
* RLC[4] P1A-P2B
Rrlc4 P1A nrlc4_1 1.08190565814e+12
Lrlc4 nrlc4_1 nrlc4_2 0.936207723689
Crlc4 nrlc4_2 P2B 1.10072436593e-07
* RLC[5] P1A-P3B
Rrlc5 P1A nrlc5_1 1.08131350303e+12
Lrlc5 nrlc5_1 nrlc5_2 0.798366738063
Crlc5 nrlc5_2 P3B 0.000430020726986
* RLC[6] P1A-P4B
Rrlc6 P1A nrlc6_1 295.870503865
Lrlc6 nrlc6_1 nrlc6_2 1.60027114189e-07
Crlc6 nrlc6_2 P4B 5.61459426755e-12
* RLC[10] P1A-rlc3
Rrlc10 P1A nrlc10_1 99868.4328666
Lrlc10 nrlc10_1 nrlc10_2 1
Crlc10 nrlc10_2 rlc3 1.1140406053e-13
* RLC[12] P1A-rlc5
Rrlc12 P1A nrlc12_1 1196525.65882
Lrlc12 nrlc12_1 nrlc12_2 1
Crlc12 nrlc12_2 rlc5 7.76092449142e-16
* RLC[14] P1A-rlc7
Rrlc14 P1A nrlc14_1 338682.109264
Lrlc14 nrlc14_1 nrlc14_2 1
Crlc14 nrlc14_2 rlc7 9.68663596817e-15
* RLC[17] P1A-rlc10
Rrlc17 P1A nrlc17_1 89898.3746499
Lrlc17 nrlc17_1 nrlc17_2 1
Crlc17 nrlc17_2 rlc10 1.37484522902e-13
* RLC[19] P1A-rlc12
Rrlc19 P1A nrlc19_1 240184.131587
Lrlc19 nrlc19_1 nrlc19_2 1
Crlc19 nrlc19_2 rlc12 1.92605581435e-14
* RLC[24] P2A-P3A
Rrlc24 P2A nrlc24_1 158875.977404
Lrlc24 nrlc24_1 nrlc24_2 7.65192786177e-10
Crlc24 nrlc24_2 P3A 1.4136810306e-12
* RLC[25] P2A-P4A
Rrlc25 P2A nrlc25_1 1e+15
Lrlc25 nrlc25_1 nrlc25_2 0.994416879845
Crlc25 nrlc25_2 P4A 7.64260264948e-10
* RLC[26] P2A-P1B
Rrlc26 P2A nrlc26_1 10.1489242739
Lrlc26 nrlc26_1 nrlc26_2 4.9808294611e-07
Crlc26 nrlc26_2 P1B 5.37302843141e-12
* RLC[27] P2A-P2B
Rrlc27 P2A nrlc27_1 1.08178856699e+12
Lrlc27 nrlc27_1 nrlc27_2 0.95752381054
Crlc27 nrlc27_2 P2B 1.36624642042e-07
* RLC[28] P2A-P3B
Rrlc28 P2A nrlc28_1 43771.5299486
Lrlc28 nrlc28_1 nrlc28_2 1
Crlc28 nrlc28_2 P3B 5.79927945478e-13
* RLC[29] P2A-P4B
Rrlc29 P2A nrlc29_1 1.08209702431e+12
Lrlc29 nrlc29_1 nrlc29_2 1
Crlc29 nrlc29_2 P4B 8.39764341724e-08
* RLC[31] P2A-rlc1
Rrlc31 P2A nrlc31_1 242567.752967
Lrlc31 nrlc31_1 nrlc31_2 1
Crlc31 nrlc31_2 rlc1 1.88838855798e-14
* RLC[34] P2A-rlc4
Rrlc34 P2A nrlc34_1 97111.0541902
Lrlc34 nrlc34_1 nrlc34_2 1
Crlc34 nrlc34_2 rlc4 1.17820307885e-13
* RLC[36] P2A-rlc6
Rrlc36 P2A nrlc36_1 478953.18193
Lrlc36 nrlc36_1 nrlc36_2 1
Crlc36 nrlc36_2 rlc6 4.84363451078e-15
* RLC[48] P3A-P1B
Rrlc48 P3A nrlc48_1 1328.13506981
Lrlc48 nrlc48_1 nrlc48_2 1.06694309313e-05
Crlc48 nrlc48_2 P1B 4.61115166308e-12
* RLC[49] P3A-P2B
Rrlc49 P3A nrlc49_1 427808.502156
Lrlc49 nrlc49_1 nrlc49_2 1
Crlc49 nrlc49_2 P2B 6.07097812197e-15
* RLC[50] P3A-P3B
Rrlc50 P3A nrlc50_1 142824408537
Lrlc50 nrlc50_1 nrlc50_2 0.99986023953
Crlc50 nrlc50_2 P3B 8.98483025641e-07
* RLC[51] P3A-P4B
Rrlc51 P3A nrlc51_1 4.67080190974
Lrlc51 nrlc51_1 nrlc51_2 2.51086572511e-07
Crlc51 nrlc51_2 P4B 1.27878661148e-11
* RLC[59] P3A-rlc7
Rrlc59 P3A nrlc59_1 4245345.08455
Lrlc59 nrlc59_1 nrlc59_2 0.999997905035
Crlc59 nrlc59_2 rlc7 6.1649645707e-17
* RLC[62] P3A-rlc10
Rrlc62 P3A nrlc62_1 1842353.94554
Lrlc62 nrlc62_1 nrlc62_2 1
Crlc62 nrlc62_2 rlc10 3.2734925211e-16
* RLC[64] P3A-rlc12
Rrlc64 P3A nrlc64_1 847012.169467
Lrlc64 nrlc64_1 nrlc64_2 1
Crlc64 nrlc64_2 rlc12 1.54873884146e-15
* RLC[69] P4A-P1B
Rrlc69 P4A nrlc69_1 23319210337.2
Lrlc69 nrlc69_1 nrlc69_2 0.988326696431
Crlc69 nrlc69_2 P1B 2.29430682712e-06
* RLC[70] P4A-P2B
Rrlc70 P4A nrlc70_1 104705359083
Lrlc70 nrlc70_1 nrlc70_2 0.154581752776
Crlc70 nrlc70_2 P2B 4.53362631109e-08
* RLC[71] P4A-P3B
Rrlc71 P4A nrlc71_1 5.30709706619e+12
Lrlc71 nrlc71_1 nrlc71_2 0.622659216428
Crlc71 nrlc71_2 P3B 3.43220985251e-11
* RLC[72] P4A-P4B
Rrlc72 P4A nrlc72_1 2.05023054731e+12
Lrlc72 nrlc72_1 nrlc72_2 0.999997501945
Crlc72 nrlc72_2 P4B 1.3721517603e-10
* RLC[82] P4A-rlc9
Rrlc82 P4A nrlc82_1 215388.374304
Lrlc82 nrlc82_1 nrlc82_2 1
Crlc82 nrlc82_2 rlc9 2.3950411187e-14
* RLC[93] P1B-rlc0
Rrlc93 P1B nrlc93_1 600149.52727
Lrlc93 nrlc93_1 nrlc93_2 1
Crlc93 nrlc93_2 rlc0 3.08488198156e-15
* RLC[96] P1B-rlc3
Rrlc96 P1B nrlc96_1 467416.017773
Lrlc96 nrlc96_1 nrlc96_2 1
Crlc96 nrlc96_2 rlc3 5.08569496966e-15
* RLC[98] P1B-rlc5
Rrlc98 P1B nrlc98_1 426434.459417
Lrlc98 nrlc98_1 nrlc98_2 1
Crlc98 nrlc98_2 rlc5 6.11016455509e-15
* RLC[110] P2B-P3B
Rrlc110 P2B nrlc110_1 29823.480963
Lrlc110 nrlc110_1 nrlc110_2 1
Crlc110 nrlc110_2 P3B 0.000162132175447
* RLC[111] P2B-P4B
Rrlc111 P2B nrlc111_1 0.0124568219906
Lrlc111 nrlc111_1 nrlc111_2 5.07814976112e-08
Crlc111 nrlc111_2 P4B 0.001
* RLC[113] P2B-rlc1
Rrlc113 P2B nrlc113_1 426401.883172
Lrlc113 nrlc113_1 nrlc113_2 1
Crlc113 nrlc113_2 rlc1 6.11109819927e-15
* RLC[115] P2B-rlc3
Rrlc115 P2B nrlc115_1 467416.147918
Lrlc115 nrlc115_1 nrlc115_2 1
Crlc115 nrlc115_2 rlc3 5.08569213759e-15
* RLC[117] P2B-rlc5
Rrlc117 P2B nrlc117_1 0.00346138472545
Lrlc117 nrlc117_1 nrlc117_2 5.36130547885e-14
Crlc117 nrlc117_2 rlc5 4.97196769487e-12
* RLC[124] P2B-rlc12
Rrlc124 P2B nrlc124_1 378591.497868
Lrlc124 nrlc124_1 nrlc124_2 1
Crlc124 nrlc124_2 rlc12 7.75203593463e-15
* RLC[129] P3B-P4B
Rrlc129 P3B nrlc129_1 0.102306672488
Lrlc129 nrlc129_1 nrlc129_2 1.3813175026e-07
Crlc129 nrlc129_2 P4B 4.24154887903e-05
* RLC[131] P3B-rlc1
Rrlc131 P3B nrlc131_1 192930.304348
Lrlc131 nrlc131_1 nrlc131_2 1
Crlc131 nrlc131_2 rlc1 2.98508424131e-14
* RLC[136] P3B-rlc6
Rrlc136 P3B nrlc136_1 172586.798947
Lrlc136 nrlc136_1 nrlc136_2 1
Crlc136 nrlc136_2 rlc6 3.73028782737e-14
* RLC[137] P3B-rlc7
Rrlc137 P3B nrlc137_1 301841.509081
Lrlc137 nrlc137_1 nrlc137_2 1
Crlc137 nrlc137_2 rlc7 1.21954986815e-14
* RLC[140] P3B-rlc10
Rrlc140 P3B nrlc140_1 848081.819408
Lrlc140 nrlc140_1 nrlc140_2 1
Crlc140 nrlc140_2 rlc10 1.54483458678e-15
* RLC[142] P3B-rlc12
Rrlc142 P3B nrlc142_1 5716.7652956
Lrlc142 nrlc142_1 nrlc142_2 1.62154302976e-06
Crlc142 nrlc142_2 rlc12 1.75154156956e-14
* RLC[143] P3B-rlc13
Rrlc143 P3B nrlc143_1 535627.385671
Lrlc143 nrlc143_1 nrlc143_2 1
Crlc143 nrlc143_2 rlc13 3.87286129647e-15
* RLC[149] P4B-rlc2
Rrlc149 P4B nrlc149_1 2681491.19569
Lrlc149 nrlc149_1 nrlc149_2 1
Crlc149 nrlc149_2 rlc2 1.5452713044e-16
* RLC[159] P4B-rlc12
Rrlc159 P4B nrlc159_1 1066117.8719
Lrlc159 nrlc159_1 nrlc159_2 1
Crlc159 nrlc159_2 rlc12 9.77568149266e-16
* RLC[161] P4B-rlc14
Rrlc161 P4B nrlc161_1 87304.8046495
Lrlc161 nrlc161_1 nrlc161_2 1
Crlc161 nrlc161_2 rlc14 1.45774379247e-13
* RLC[163] P4B-GND
Rrlc163 P4B nrlc163_1 755407.153802
Lrlc163 nrlc163_1 nrlc163_2 1
Crlc163 nrlc163_2 GND 1.94713159503e-15
* RLC[164] rlc0-rlc1
Rrlc164 rlc0 nrlc164_1 2.22116249586
Lrlc164 nrlc164_1 nrlc164_2 0.027189228505
Crlc164 nrlc164_2 rlc1 6.12341525117e-06
* RLC[175] rlc0-rlc12
Rrlc175 rlc0 nrlc175_1 0.892196713312
Lrlc175 nrlc175_1 nrlc175_2 0.282242951348
Crlc175 nrlc175_2 rlc12 0.000393966557198
* RLC[179] rlc0-GND
Rrlc179 rlc0 nrlc179_1 0.00744059912994
Lrlc179 nrlc179_1 nrlc179_2 4.98262638713e-05
Crlc179 nrlc179_2 GND 0.001
* RLC[180] rlc1-rlc2
Rrlc180 rlc1 nrlc180_1 1.54685649541
Lrlc180 nrlc180_1 nrlc180_2 0.0527548798479
Crlc180 nrlc180_2 rlc2 2.44974047758e-05
* RLC[181] rlc1-rlc3
Rrlc181 rlc1 nrlc181_1 513.634308969
Lrlc181 nrlc181_1 nrlc181_2 1
Crlc181 nrlc181_2 rlc3 4.2116225255e-09
* RLC[182] rlc1-rlc4
Rrlc182 rlc1 nrlc182_1 2.23953798166
Lrlc182 nrlc182_1 nrlc182_2 0.0335919175217
Crlc182 nrlc182_2 rlc4 7.44175591385e-06
* RLC[185] rlc1-rlc7
Rrlc185 rlc1 nrlc185_1 0.722963331564
Lrlc185 nrlc185_1 nrlc185_2 0.0315433601315
Crlc185 nrlc185_2 rlc7 6.70552681708e-05
* RLC[187] rlc1-rlc9
Rrlc187 rlc1 nrlc187_1 7.38369297789
Lrlc187 nrlc187_1 nrlc187_2 1.98562152494e-06
Crlc187 nrlc187_2 rlc9 4.04675305054e-11
* RLC[188] rlc1-rlc10
Rrlc188 rlc1 nrlc188_1 29.402212535
Lrlc188 nrlc188_1 nrlc188_2 1
Crlc188 nrlc188_2 rlc10 1.28527915889e-06
* RLC[189] rlc1-rlc11
Rrlc189 rlc1 nrlc189_1 7766.02961917
Lrlc189 nrlc189_1 nrlc189_2 0.00355142020837
Crlc189 nrlc189_2 rlc11 6.54276718736e-14
* RLC[190] rlc1-rlc12
Rrlc190 rlc1 nrlc190_1 6.03402896685
Lrlc190 nrlc190_1 nrlc190_2 0.0225788301617
Crlc190 nrlc190_2 rlc12 6.89039542665e-07
* RLC[192] rlc1-rlc14
Rrlc192 rlc1 nrlc192_1 12.9665032363
Lrlc192 nrlc192_1 nrlc192_2 0.00997308980631
Crlc192 nrlc192_2 rlc14 6.59085071499e-08
* RLC[193] rlc1-rlc15
Rrlc193 rlc1 nrlc193_1 1132.24646111
Lrlc193 nrlc193_1 nrlc193_2 0.00042345987893
Crlc193 nrlc193_2 rlc15 3.67018381471e-13
* RLC[194] rlc1-GND
Rrlc194 rlc1 nrlc194_1 0.198160317411
Lrlc194 nrlc194_1 nrlc194_2 0.0353008147395
Crlc194 nrlc194_2 GND 0.000998869704079
* RLC[204] rlc2-rlc12
Rrlc204 rlc2 nrlc204_1 0.784354959777
Lrlc204 nrlc204_1 nrlc204_2 0.548481324559
Crlc204 nrlc204_2 rlc12 0.000990590231727
* RLC[205] rlc2-rlc13
Rrlc205 rlc2 nrlc205_1 0.757275946678
Lrlc205 nrlc205_1 nrlc205_2 0.000380622999791
Crlc205 nrlc205_2 rlc13 7.37469719945e-07
* RLC[206] rlc2-rlc14
Rrlc206 rlc2 nrlc206_1 314336.315435
Lrlc206 nrlc206_1 nrlc206_2 1
Crlc206 nrlc206_2 rlc14 1.12452308199e-14
* RLC[211] rlc3-rlc6
Rrlc211 rlc3 nrlc211_1 11.4616537832
Lrlc211 nrlc211_1 nrlc211_2 1
Crlc211 nrlc211_2 rlc6 8.45790726261e-06
* RLC[214] rlc3-rlc9
Rrlc214 rlc3 nrlc214_1 26.0125100596
Lrlc214 nrlc214_1 nrlc214_2 1.33036076566e-07
Crlc214 nrlc214_2 rlc9 2.1845520489e-13
* RLC[219] rlc3-rlc14
Rrlc219 rlc3 nrlc219_1 145149.631865
Lrlc219 nrlc219_1 nrlc219_2 0.0397182451074
Crlc219 nrlc219_2 rlc14 2.09467025081e-15
* RLC[221] rlc3-GND
Rrlc221 rlc3 nrlc221_1 15.9207346548
Lrlc221 nrlc221_1 nrlc221_2 1
Crlc221 nrlc221_2 GND 4.38360367353e-06
* RLC[225] rlc4-rlc8
Rrlc225 rlc4 nrlc225_1 0.178281034057
Lrlc225 nrlc225_1 nrlc225_2 8.5713375118e-06
Crlc225 nrlc225_2 rlc8 2.99637247081e-07
* RLC[229] rlc4-rlc12
Rrlc229 rlc4 nrlc229_1 4.72665914799
Lrlc229 nrlc229_1 nrlc229_2 0.29485045321
Crlc229 nrlc229_2 rlc12 1.46639415079e-05
* RLC[232] rlc4-rlc15
Rrlc232 rlc4 nrlc232_1 0.00344694087789
Lrlc232 nrlc232_1 nrlc232_2 6.03966527614e-09
Crlc232 nrlc232_2 rlc15 5.64810409221e-07
* RLC[237] rlc5-rlc9
Rrlc237 rlc5 nrlc237_1 0.0001
Lrlc237 nrlc237_1 nrlc237_2 3.99726681446e-13
Crlc237 nrlc237_2 rlc9 2.54794506113e-05
* RLC[239] rlc5-rlc11
Rrlc239 rlc5 nrlc239_1 0.0108914737974
Lrlc239 nrlc239_1 nrlc239_2 3.85440918955e-11
Crlc239 nrlc239_2 rlc11 3.61028932029e-10
* RLC[240] rlc5-rlc12
Rrlc240 rlc5 nrlc240_1 44.9188818983
Lrlc240 nrlc240_1 nrlc240_2 0.171573028598
Crlc240 nrlc240_2 rlc12 9.44819032467e-08
* RLC[246] rlc6-rlc8
Rrlc246 rlc6 nrlc246_1 2.60512494383
Lrlc246 nrlc246_1 nrlc246_2 2.39955854249e-07
Crlc246 nrlc246_2 rlc8 3.92854494445e-11
* RLC[250] rlc6-rlc12
Rrlc250 rlc6 nrlc250_1 36.1967130401
Lrlc250 nrlc250_1 nrlc250_2 0.221878425528
Crlc250 nrlc250_2 rlc12 1.88163029328e-07
* RLC[256] rlc7-rlc9
Rrlc256 rlc7 nrlc256_1 0.0140285195248
Lrlc256 nrlc256_1 nrlc256_2 4.15266411831e-05
Crlc256 nrlc256_2 rlc9 0.000234455601949
* RLC[258] rlc7-rlc11
Rrlc258 rlc7 nrlc258_1 110974.567085
Lrlc258 nrlc258_1 nrlc258_2 0.000200719473094
Crlc258 nrlc258_2 rlc11 1.43379147088e-14
* RLC[259] rlc7-rlc12
Rrlc259 rlc7 nrlc259_1 84.6476489517
Lrlc259 nrlc259_1 nrlc259_2 1.52787483285e-05
Crlc259 nrlc259_2 rlc12 2.36927497464e-12
* RLC[261] rlc7-rlc14
Rrlc261 rlc7 nrlc261_1 2.11668813884
Lrlc261 nrlc261_1 nrlc261_2 0.0122916263439
Crlc261 nrlc261_2 rlc14 3.04826758433e-06
* RLC[264] rlc8-rlc9
Rrlc264 rlc8 nrlc264_1 0.000978351606706
Lrlc264 nrlc264_1 nrlc264_2 6.00157483652e-08
Crlc264 nrlc264_2 rlc9 6.96679114744e-05
* RLC[267] rlc8-rlc12
Rrlc267 rlc8 nrlc267_1 34.2744744136
Lrlc267 nrlc267_1 nrlc267_2 0.307229325388
Crlc267 nrlc267_2 rlc12 2.90588585049e-07
* RLC[271] rlc8-GND
Rrlc271 rlc8 nrlc271_1 0.0205631799289
Lrlc271 nrlc271_1 nrlc271_2 5.65950523985e-07
Crlc271 nrlc271_2 GND 1.487152158e-06
* RLC[275] rlc9-rlc13
Rrlc275 rlc9 nrlc275_1 7.00732468413
Lrlc275 nrlc275_1 nrlc275_2 0.00202694334623
Crlc275 nrlc275_2 rlc13 4.58663962593e-08
* RLC[280] rlc10-rlc12
Rrlc280 rlc10 nrlc280_1 1.14174824643
Lrlc280 nrlc280_1 nrlc280_2 1
Crlc280 nrlc280_2 rlc12 0.000852347681269
* RLC[284] rlc10-GND
Rrlc284 rlc10 nrlc284_1 1.12250822334
Lrlc284 nrlc284_1 nrlc284_2 1
Crlc284 nrlc284_2 GND 0.000881816920739
* RLC[285] rlc11-rlc12
Rrlc285 rlc11 nrlc285_1 110.123253352
Lrlc285 nrlc285_1 nrlc285_2 0.267173064976
Crlc285 nrlc285_2 rlc12 2.44789111974e-08
* RLC[289] rlc11-GND
Rrlc289 rlc11 nrlc289_1 175.167902119
Lrlc289 nrlc289_1 nrlc289_2 2.14580471427e-05
Crlc289 nrlc289_2 GND 7.77031505792e-13
* RLC[291] rlc12-rlc14
Rrlc291 rlc12 nrlc291_1 1648.41388729
Lrlc291 nrlc291_1 nrlc291_2 1
Crlc291 nrlc291_2 rlc14 4.08907391734e-10
* RLC[292] rlc12-rlc15
Rrlc292 rlc12 nrlc292_1 0.737354084953
Lrlc292 nrlc292_1 nrlc292_2 0.283360787472
Crlc292 nrlc292_2 rlc15 0.000579088659606
* RLC[299] rlc15-GND
Rrlc299 rlc15 nrlc299_1 0.0134499790146
Lrlc299 nrlc299_1 nrlc299_2 2.134509841e-09
Crlc299 nrlc299_2 GND 1.31102942301e-08
* DC[0] P1A-P2A
Rdc0 P1A ndc0_1 0.0863300701056
Ldc0 ndc0_1 P2A 1.06068565796e-07
* DC[1] P1A-P3A
Rdc1 P1A ndc1_1 1e+15
Ldc1 ndc1_1 P3A 1
* DC[2] P1A-P4A
Rdc2 P1A ndc2_1 1e+15
Ldc2 ndc2_1 P4A 1
* DC[4] P1A-P2B
Rdc4 P1A ndc4_1 1.08132117386e+12
Ldc4 ndc4_1 P2B 1
* DC[5] P1A-P3B
Rdc5 P1A ndc5_1 1.08132133266e+12
Ldc5 ndc5_1 P3B 1
* DC[8] P1A-dc1
Rdc8 P1A ndc8_1 1.08132395318e+12
Ldc8 ndc8_1 dc1 1
* DC[9] P1A-dc2
Rdc9 P1A ndc9_1 1.0813239944e+12
Ldc9 ndc9_1 dc2 1
* DC[10] P1A-dc3
Rdc10 P1A ndc10_1 1.08132397748e+12
Ldc10 ndc10_1 dc3 1
* DC[13] P2A-P4A
Rdc13 P2A ndc13_1 1e+15
Ldc13 ndc13_1 P4A 1
* DC[15] P2A-P2B
Rdc15 P2A ndc15_1 1.08132212846e+12
Ldc15 ndc15_1 P2B 1
* DC[17] P2A-P4B
Rdc17 P2A ndc17_1 1.08132072437e+12
Ldc17 ndc17_1 P4B 1
* DC[18] P2A-dc0
Rdc18 P2A ndc18_1 1.08132290584e+12
Ldc18 ndc18_1 dc0 1
* DC[19] P2A-dc1
Rdc19 P2A ndc19_1 1.0813207995e+12
Ldc19 ndc19_1 dc1 1
* DC[20] P2A-dc2
Rdc20 P2A ndc20_1 1.08132078031e+12
Ldc20 ndc20_1 dc2 1
* DC[21] P2A-dc3
Rdc21 P2A ndc21_1 1.08132078092e+12
Ldc21 ndc21_1 dc3 1
* DC[23] P3A-P4A
Rdc23 P3A ndc23_1 0.129897371397
Ldc23 ndc23_1 P4A 1.57055198073e-07
* DC[29] P3A-dc1
Rdc29 P3A ndc29_1 1.52982081482e+13
Ldc29 ndc29_1 dc1 1
* DC[33] P4A-P1B
Rdc33 P4A ndc33_1 840862395416
Ldc33 ndc33_1 P1B 1
* DC[34] P4A-P2B
Rdc34 P4A ndc34_1 1.53007170205e+13
Ldc34 ndc34_1 P2B 1
* DC[35] P4A-P3B
Rdc35 P4A ndc35_1 1.52974681869e+13
Ldc35 ndc35_1 P3B 1
* DC[36] P4A-P4B
Rdc36 P4A ndc36_1 1.52975871771e+13
Ldc36 ndc36_1 P4B 1
* DC[37] P4A-dc0
Rdc37 P4A ndc37_1 1.52976656345e+13
Ldc37 ndc37_1 dc0 1
* DC[38] P4A-dc1
Rdc38 P4A ndc38_1 1.53291751655e+13
Ldc38 ndc38_1 dc1 1
* DC[39] P4A-dc2
Rdc39 P4A ndc39_1 1.76870717681e+13
Ldc39 ndc39_1 dc2 1
* DC[40] P4A-dc3
Rdc40 P4A ndc40_1 1.52983662896e+13
Ldc40 ndc40_1 dc3 1
* DC[42] P1B-P2B
Rdc42 P1B ndc42_1 0.0836469873292
Ldc42 ndc42_1 P2B 1.00620771095e-07
* DC[43] P1B-P3B
Rdc43 P1B ndc43_1 0.000646799251059
Ldc43 ndc43_1 P3B 4.25461205543e-09
* DC[45] P1B-dc0
Rdc45 P1B ndc45_1 0.00213980046611
Ldc45 ndc45_1 dc0 3.67486040285e-08
* DC[47] P1B-dc2
Rdc47 P1B ndc47_1 8455105871.84
Ldc47 ndc47_1 dc2 1
* DC[51] P2B-P4B
Rdc51 P2B ndc51_1 0.00416486919266
Ldc51 ndc51_1 P4B 2.09937771502e-08
* DC[53] P2B-dc1
Rdc53 P2B ndc53_1 0.000462851829228
Ldc53 ndc53_1 dc1 4.66577627158e-09
* DC[54] P2B-dc2
Rdc54 P2B ndc54_1 55223.9295547
Ldc54 ndc54_1 dc2 1
* DC[55] P2B-dc3
Rdc55 P2B ndc55_1 0.00635662287336
Ldc55 ndc55_1 dc3 5.4200291644e-08
* DC[58] P3B-dc0
Rdc58 P3B ndc58_1 0.00208403599066
Ldc58 ndc58_1 dc0 3.31684629494e-10
* DC[59] P3B-dc1
Rdc59 P3B ndc59_1 0.00731894718223
Ldc59 ndc59_1 dc1 3.81167209348e-07
* DC[60] P3B-dc2
Rdc60 P3B ndc60_1 3.06235952193
Ldc60 ndc60_1 dc2 1.3521694046e-06
* DC[61] P3B-dc3
Rdc61 P3B ndc61_1 0.0282649319007
Ldc61 ndc61_1 dc3 1.62731069178e-06
* DC[64] P4B-dc1
Rdc64 P4B ndc64_1 0.000544837677471
Ldc64 ndc64_1 dc1 8.67136095522e-11
* DC[65] P4B-dc2
Rdc65 P4B ndc65_1 0.00125211141519
Ldc65 ndc65_1 dc2 1.99279721028e-10
* DC[66] P4B-dc3
Rdc66 P4B ndc66_1 0.00222254082856
Ldc66 ndc66_1 dc3 3.53728359088e-10
* DC[69] dc0-dc2
Rdc69 dc0 ndc69_1 0.000100062677675
Ldc69 ndc69_1 dc2 4.40445391827e-08
* DC[72] dc1-dc2
Rdc72 dc1 ndc72_1 0.000152361660187
Ldc72 ndc72_1 dc2 7.13767808917e-09
* DC[73] dc1-dc3
Rdc73 dc1 ndc73_1 0.00115205973476
Ldc73 ndc73_1 dc3 1.83356001524e-10
* DC[75] dc2-dc3
Rdc75 dc2 ndc75_1 0.000299193777824
Ldc75 ndc75_1 dc3 4.98949434113e-08
* ---- leaks
Rleak_P1A P1A GND 1e+12
Rleak_P1B P1B GND 1e+12
Rleak_P2A P2A GND 1e+12
Rleak_P2B P2B GND 1e+12
Rleak_P3A P3A GND 1e+12
Rleak_P3B P3B GND 1e+12
Rleak_P4A P4A GND 1e+12
Rleak_P4B P4B GND 1e+12
Rleak_dc0 dc0 GND 1e+12
Rleak_dc1 dc1 GND 1e+12
Rleak_dc2 dc2 GND 1e+12
Rleak_dc3 dc3 GND 1e+12
Rleak_rlc0 rlc0 GND 1e+12
Rleak_rlc1 rlc1 GND 1e+12
Rleak_rlc10 rlc10 GND 1e+12
Rleak_rlc11 rlc11 GND 1e+12
Rleak_rlc12 rlc12 GND 1e+12
Rleak_rlc13 rlc13 GND 1e+12
Rleak_rlc14 rlc14 GND 1e+12
Rleak_rlc15 rlc15 GND 1e+12
Rleak_rlc2 rlc2 GND 1e+12
Rleak_rlc3 rlc3 GND 1e+12
Rleak_rlc4 rlc4 GND 1e+12
Rleak_rlc5 rlc5 GND 1e+12
Rleak_rlc6 rlc6 GND 1e+12
Rleak_rlc7 rlc7 GND 1e+12
Rleak_rlc8 rlc8 GND 1e+12
Rleak_rlc9 rlc9 GND 1e+12
.ends fitted
