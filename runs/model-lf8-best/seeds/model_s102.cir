* fitted: 8-port fitted model, reference z0 = 50 Ohm
* every pin is a port against GND
.subckt fitted P1A P1B P2A P2B P3A P3B P4A P4B GND
* ---- branches
* RLC[0] P1A-P2A
Rrlc0 P1A nrlc0_1 0.779892254518
Lrlc0 nrlc0_1 nrlc0_2 2.99485843841e-07
Crlc0 nrlc0_2 P2A 2.9500588877e-06
* RLC[1] P1A-P3A
Rrlc1 P1A nrlc1_1 3.54366990666e+12
Lrlc1 nrlc1_1 nrlc1_2 0.242006767114
Crlc1 nrlc1_2 P3A 0.000999979865708
* RLC[2] P1A-P4A
Rrlc2 P1A nrlc2_1 198545982468
Lrlc2 nrlc2_1 nrlc2_2 0.792745694793
Crlc2 nrlc2_2 P4A 6.37410664464e-12
* RLC[3] P1A-P1B
Rrlc3 P1A nrlc3_1 2.42335382313e+13
Lrlc3 nrlc3_1 nrlc3_2 0.0670864993892
Crlc3 nrlc3_2 P1B 1.08384221938e-10
* RLC[4] P1A-P2B
Rrlc4 P1A nrlc4_1 4.53887341361
Lrlc4 nrlc4_1 nrlc4_2 2.27084300481e-07
Crlc4 nrlc4_2 P2B 1.2247528518e-11
* RLC[5] P1A-P3B
Rrlc5 P1A nrlc5_1 11354.9885439
Lrlc5 nrlc5_1 nrlc5_2 0.105506123938
Crlc5 nrlc5_2 P3B 9.09204880051e-13
* RLC[6] P1A-P4B
Rrlc6 P1A nrlc6_1 2.95833191746e+12
Lrlc6 nrlc6_1 nrlc6_2 0.990603919543
Crlc6 nrlc6_2 P4B 1.91672768345e-09
* RLC[7] P1A-rlc0
Rrlc7 P1A nrlc7_1 36018.443265
Lrlc7 nrlc7_1 nrlc7_2 0.11588252925
Crlc7 nrlc7_2 rlc0 9.9248871913e-14
* RLC[8] P1A-rlc1
Rrlc8 P1A nrlc8_1 8.72102541776e+12
Lrlc8 nrlc8_1 nrlc8_2 9.10538268172e-08
Crlc8 nrlc8_2 rlc1 4.38844833855e-09
* RLC[10] P1A-rlc3
Rrlc10 P1A nrlc10_1 22442.9044284
Lrlc10 nrlc10_1 nrlc10_2 1
Crlc10 nrlc10_2 rlc3 2.20596882402e-12
* RLC[11] P1A-rlc4
Rrlc11 P1A nrlc11_1 22844.272014
Lrlc11 nrlc11_1 nrlc11_2 1
Crlc11 nrlc11_2 rlc4 2.12913326328e-12
* RLC[12] P1A-rlc5
Rrlc12 P1A nrlc12_1 12873.6338359
Lrlc12 nrlc12_1 nrlc12_2 6.11401077675e-11
Crlc12 nrlc12_2 rlc5 4.58006233929e-15
* RLC[17] P1A-rlc10
Rrlc17 P1A nrlc17_1 16122.2739737
Lrlc17 nrlc17_1 nrlc17_2 0.0103421325201
Crlc17 nrlc17_2 rlc10 4.42094380717e-14
* RLC[18] P1A-rlc11
Rrlc18 P1A nrlc18_1 1.20029247256e+13
Lrlc18 nrlc18_1 nrlc18_2 0.999997905789
Crlc18 nrlc18_2 rlc11 8.88069910348e-06
* RLC[19] P1A-rlc12
Rrlc19 P1A nrlc19_1 1.13430218658e+13
Lrlc19 nrlc19_1 nrlc19_2 5.28732662879e-05
Crlc19 nrlc19_2 rlc12 1.00799639639e-09
* RLC[24] P2A-P3A
Rrlc24 P2A nrlc24_1 3.82980960854e+12
Lrlc24 nrlc24_1 nrlc24_2 0.375473785818
Crlc24 nrlc24_2 P3A 6.93179800896e-07
* RLC[25] P2A-P4A
Rrlc25 P2A nrlc25_1 676.494202404
Lrlc25 nrlc25_1 nrlc25_2 8.80631863265e-07
Crlc25 nrlc25_2 P4A 2.16632413015e-12
* RLC[26] P2A-P1B
Rrlc26 P2A nrlc26_1 555627729421
Lrlc26 nrlc26_1 nrlc26_2 0.373789334559
Crlc26 nrlc26_2 P1B 4.90398407551e-08
* RLC[27] P2A-P2B
Rrlc27 P2A nrlc27_1 28121422350.3
Lrlc27 nrlc27_1 nrlc27_2 1
Crlc27 nrlc27_2 P2B 3.57969712063e-05
* RLC[28] P2A-P3B
Rrlc28 P2A nrlc28_1 300786446806
Lrlc28 nrlc28_1 nrlc28_2 0.932239744064
Crlc28 nrlc28_2 P3B 1.44589201547e-07
* RLC[29] P2A-P4B
Rrlc29 P2A nrlc29_1 154987193086
Lrlc29 nrlc29_1 nrlc29_2 0.627093214119
Crlc29 nrlc29_2 P4B 4.3447375159e-06
* RLC[33] P2A-rlc3
Rrlc33 P2A nrlc33_1 215.275992085
Lrlc33 nrlc33_1 nrlc33_2 1.16557853059e-06
Crlc33 nrlc33_2 rlc3 2.79452391932e-14
* RLC[34] P2A-rlc4
Rrlc34 P2A nrlc34_1 22844.2753777
Lrlc34 nrlc34_1 nrlc34_2 1
Crlc34 nrlc34_2 rlc4 2.12913263627e-12
* RLC[36] P2A-rlc6
Rrlc36 P2A nrlc36_1 12652.436852
Lrlc36 nrlc36_1 nrlc36_2 2.55436204128e-05
Crlc36 nrlc36_2 rlc6 3.39546616186e-14
* RLC[40] P2A-rlc10
Rrlc40 P2A nrlc40_1 32646.8393207
Lrlc40 nrlc40_1 nrlc40_2 1
Crlc40 nrlc40_2 rlc10 1.04249794381e-12
* RLC[41] P2A-rlc11
Rrlc41 P2A nrlc41_1 22413.0213377
Lrlc41 nrlc41_1 nrlc41_2 1
Crlc41 nrlc41_2 rlc11 2.21185514442e-12
* RLC[47] P3A-P4A
Rrlc47 P3A nrlc47_1 4.14024748933
Lrlc47 nrlc47_1 nrlc47_2 8.19814081233e-07
Crlc47 nrlc47_2 P4A 3.94533130575e-07
* RLC[48] P3A-P1B
Rrlc48 P3A nrlc48_1 4276.69834519
Lrlc48 nrlc48_1 nrlc48_2 0.000449721609923
Crlc48 nrlc48_2 P1B 2.73202085402e-14
* RLC[51] P3A-P4B
Rrlc51 P3A nrlc51_1 75.3396121903
Lrlc51 nrlc51_1 nrlc51_2 6.09514994833e-06
Crlc51 nrlc51_2 P4B 1.19315021583e-12
* RLC[61] P3A-rlc9
Rrlc61 P3A nrlc61_1 556446.473992
Lrlc61 nrlc61_1 nrlc61_2 1
Crlc61 nrlc61_2 rlc9 3.5884814122e-15
* RLC[62] P3A-rlc10
Rrlc62 P3A nrlc62_1 125151.278816
Lrlc62 nrlc62_1 nrlc62_2 0.0122768178979
Crlc62 nrlc62_2 rlc10 8.70908885003e-16
* RLC[64] P3A-rlc12
Rrlc64 P3A nrlc64_1 705598.74388
Lrlc64 nrlc64_1 nrlc64_2 1
Crlc64 nrlc64_2 rlc12 2.23173123908e-15
* RLC[66] P3A-rlc14
Rrlc66 P3A nrlc66_1 1698.87130368
Lrlc66 nrlc66_1 nrlc66_2 6.57482852173e-07
Crlc66 nrlc66_2 rlc14 4.99527485459e-13
* RLC[67] P3A-rlc15
Rrlc67 P3A nrlc67_1 96611.0219164
Lrlc67 nrlc67_1 nrlc67_2 1
Crlc67 nrlc67_2 rlc15 1.19043075568e-13
* RLC[79] P4A-rlc6
Rrlc79 P4A nrlc79_1 48313.7147185
Lrlc79 nrlc79_1 nrlc79_2 3.60606677337e-09
Crlc79 nrlc79_2 rlc6 4.69664929427e-16
* RLC[81] P4A-rlc8
Rrlc81 P4A nrlc81_1 111610.462455
Lrlc81 nrlc81_1 nrlc81_2 8.85671145849e-09
Crlc81 nrlc81_2 rlc8 2.95864236368e-20
* RLC[84] P4A-rlc11
Rrlc84 P4A nrlc84_1 9107704.84918
Lrlc84 nrlc84_1 nrlc84_2 1
Crlc84 nrlc84_2 rlc11 1.33949036585e-17
* RLC[85] P4A-rlc12
Rrlc85 P4A nrlc85_1 44351.85321
Lrlc85 nrlc85_1 nrlc85_2 1
Crlc85 nrlc85_2 rlc12 5.64851060024e-13
* RLC[96] P1B-rlc3
Rrlc96 P1B nrlc96_1 9258423.58713
Lrlc96 nrlc96_1 nrlc96_2 0.898988448796
Crlc96 nrlc96_2 rlc3 1.16529936272e-17
* RLC[97] P1B-rlc4
Rrlc97 P1B nrlc97_1 56279.2576497
Lrlc97 nrlc97_1 nrlc97_2 0.651026465995
Crlc97 nrlc97_2 rlc4 2.28380707615e-13
* RLC[99] P1B-rlc6
Rrlc99 P1B nrlc99_1 383.501422536
Lrlc99 nrlc99_1 nrlc99_2 1
Crlc99 nrlc99_2 rlc6 7.55480974932e-09
* RLC[100] P1B-rlc7
Rrlc100 P1B nrlc100_1 22038.7615087
Lrlc100 nrlc100_1 nrlc100_2 1
Crlc100 nrlc100_2 rlc7 2.28761597196e-12
* RLC[103] P1B-rlc10
Rrlc103 P1B nrlc103_1 1753.77835557
Lrlc103 nrlc103_1 nrlc103_2 0.000300607975672
Crlc103 nrlc103_2 rlc10 1.08594686979e-13
* RLC[105] P1B-rlc12
Rrlc105 P1B nrlc105_1 212.807061971
Lrlc105 nrlc105_1 nrlc105_2 1.92136424437e-13
Crlc105 nrlc105_2 rlc12 1.08222856183e-12
* RLC[108] P1B-rlc15
Rrlc108 P1B nrlc108_1 217.482919364
Lrlc108 nrlc108_1 nrlc108_2 1
Crlc108 nrlc108_2 rlc15 2.34913070995e-08
* RLC[110] P2B-P3B
Rrlc110 P2B nrlc110_1 8.39342381858
Lrlc110 nrlc110_1 nrlc110_2 3.75892059824e-08
Crlc110 nrlc110_2 P3B 4.93882922539e-11
* RLC[113] P2B-rlc1
Rrlc113 P2B nrlc113_1 40.6535116949
Lrlc113 nrlc113_1 nrlc113_2 1
Crlc113 nrlc113_2 rlc1 6.72297285596e-07
* RLC[116] P2B-rlc4
Rrlc116 P2B nrlc116_1 60617.0029909
Lrlc116 nrlc116_1 nrlc116_2 1
Crlc116 nrlc116_2 rlc4 3.02390797218e-13
* RLC[117] P2B-rlc5
Rrlc117 P2B nrlc117_1 172.612987818
Lrlc117 nrlc117_1 nrlc117_2 1
Crlc117 nrlc117_2 rlc5 3.72915599346e-08
* RLC[118] P2B-rlc6
Rrlc118 P2B nrlc118_1 16575.3518194
Lrlc118 nrlc118_1 nrlc118_2 0.0662716893856
Crlc118 nrlc118_2 rlc6 2.68015568267e-13
* RLC[119] P2B-rlc7
Rrlc119 P2B nrlc119_1 891.72126821
Lrlc119 nrlc119_1 nrlc119_2 1
Crlc119 nrlc119_2 rlc7 1.39733082784e-09
* RLC[120] P2B-rlc8
Rrlc120 P2B nrlc120_1 0.230804468082
Lrlc120 nrlc120_1 nrlc120_2 6.69776954046e-11
Crlc120 nrlc120_2 rlc8 1.39700920181e-12
* RLC[122] P2B-rlc10
Rrlc122 P2B nrlc122_1 4126.07032554
Lrlc122 nrlc122_1 nrlc122_2 0.00471788624153
Crlc122 nrlc122_2 rlc10 3.07915608105e-13
* RLC[124] P2B-rlc12
Rrlc124 P2B nrlc124_1 531.570875375
Lrlc124 nrlc124_1 nrlc124_2 1
Crlc124 nrlc124_2 rlc12 3.93219579535e-09
* RLC[126] P2B-rlc14
Rrlc126 P2B nrlc126_1 21.8924793197
Lrlc126 nrlc126_1 nrlc126_2 1
Crlc126 nrlc126_2 rlc14 2.31828910545e-06
* RLC[127] P2B-rlc15
Rrlc127 P2B nrlc127_1 36.29203666
Lrlc127 nrlc127_1 nrlc127_2 1.28490848549e-06
Crlc127 nrlc127_2 rlc15 1.08394439983e-12
* RLC[130] P3B-rlc0
Rrlc130 P3B nrlc130_1 40.6631141763
Lrlc130 nrlc130_1 nrlc130_2 1
Crlc130 nrlc130_2 rlc0 6.71979800817e-07
* RLC[132] P3B-rlc2
Rrlc132 P3B nrlc132_1 183.914788053
Lrlc132 nrlc132_1 nrlc132_2 1
Crlc132 nrlc132_2 rlc2 3.28491539534e-08
* RLC[134] P3B-rlc4
Rrlc134 P3B nrlc134_1 1725.59733138
Lrlc134 nrlc134_1 nrlc134_2 1
Crlc134 nrlc134_2 rlc4 3.73145810241e-10
* RLC[136] P3B-rlc6
Rrlc136 P3B nrlc136_1 0.00298704587607
Lrlc136 nrlc136_1 nrlc136_2 2.67765723285e-14
Crlc136 nrlc136_2 rlc6 3.33448437972e-12
* RLC[139] P3B-rlc9
Rrlc139 P3B nrlc139_1 10629.0824149
Lrlc139 nrlc139_1 nrlc139_2 1
Crlc139 nrlc139_2 rlc9 9.83480926381e-12
* RLC[141] P3B-rlc11
Rrlc141 P3B nrlc141_1 26.516436567
Lrlc141 nrlc141_1 nrlc141_2 1
Crlc141 nrlc141_2 rlc11 1.58025498603e-06
* RLC[143] P3B-rlc13
Rrlc143 P3B nrlc143_1 0.104401778673
Lrlc143 nrlc143_1 nrlc143_2 3.04182324595e-12
Crlc143 nrlc143_2 rlc13 3.10081366746e-13
* RLC[144] P3B-rlc14
Rrlc144 P3B nrlc144_1 6562.59261739
Lrlc144 nrlc144_1 nrlc144_2 1
Crlc144 nrlc144_2 rlc14 2.5799221389e-11
* RLC[146] P3B-GND
Rrlc146 P3B nrlc146_1 4805.90597437
Lrlc146 nrlc146_1 nrlc146_2 1
Crlc146 nrlc146_2 GND 4.81068533777e-11
* RLC[148] P4B-rlc1
Rrlc148 P4B nrlc148_1 315.97653542
Lrlc148 nrlc148_1 nrlc148_2 1
Crlc148 nrlc148_2 rlc1 1.11287868591e-08
* RLC[149] P4B-rlc2
Rrlc149 P4B nrlc149_1 15.2677198458
Lrlc149 nrlc149_1 nrlc149_2 1
Crlc149 nrlc149_2 rlc2 4.76660458041e-06
* RLC[151] P4B-rlc4
Rrlc151 P4B nrlc151_1 20.1469450634
Lrlc151 nrlc151_1 nrlc151_2 1
Crlc151 nrlc151_2 rlc4 2.73740518892e-06
* RLC[153] P4B-rlc6
Rrlc153 P4B nrlc153_1 21795.049027
Lrlc153 nrlc153_1 nrlc153_2 0.0122496493913
Crlc153 nrlc153_2 rlc6 2.86526931305e-14
* RLC[154] P4B-rlc7
Rrlc154 P4B nrlc154_1 2433493.97495
Lrlc154 nrlc154_1 nrlc154_2 1
Crlc154 nrlc154_2 rlc7 1.87627693539e-16
* RLC[155] P4B-rlc8
Rrlc155 P4B nrlc155_1 22.6887027226
Lrlc155 nrlc155_1 nrlc155_2 1
Crlc155 nrlc155_2 rlc8 2.15843095555e-06
* RLC[156] P4B-rlc9
Rrlc156 P4B nrlc156_1 5371.81584222
Lrlc156 nrlc156_1 nrlc156_2 1
Crlc156 nrlc156_2 rlc9 3.85048343362e-11
* RLC[160] P4B-rlc13
Rrlc160 P4B nrlc160_1 43052.0603776
Lrlc160 nrlc160_1 nrlc160_2 0.207061643678
Crlc160 nrlc160_2 rlc13 1.24127859511e-13
* RLC[161] P4B-rlc14
Rrlc161 P4B nrlc161_1 5330.48393775
Lrlc161 nrlc161_1 nrlc161_2 1
Crlc161 nrlc161_2 rlc14 3.91042726664e-11
* RLC[164] rlc0-rlc1
Rrlc164 rlc0 nrlc164_1 0.0130157067921
Lrlc164 nrlc164_1 nrlc164_2 0.000152467760968
Crlc164 nrlc164_2 rlc1 0.001
* RLC[165] rlc0-rlc2
Rrlc165 rlc0 nrlc165_1 1.28624600797
Lrlc165 nrlc165_1 nrlc165_2 1
Crlc165 nrlc165_2 rlc2 0.00067159802573
* RLC[166] rlc0-rlc3
Rrlc166 rlc0 nrlc166_1 1117.10434483
Lrlc166 nrlc166_1 nrlc166_2 1
Crlc166 nrlc166_2 rlc3 8.90368954734e-10
* RLC[168] rlc0-rlc5
Rrlc168 rlc0 nrlc168_1 3298.47353604
Lrlc168 nrlc168_1 nrlc168_2 0.000843054443841
Crlc168 nrlc168_2 rlc5 8.60968186932e-14
* RLC[169] rlc0-rlc6
Rrlc169 rlc0 nrlc169_1 1.7700275079
Lrlc169 nrlc169_1 nrlc169_2 1
Crlc169 nrlc169_2 rlc6 0.000354647954276
* RLC[170] rlc0-rlc7
Rrlc170 rlc0 nrlc170_1 1.05409255339
Lrlc170 nrlc170_1 nrlc170_2 1
Crlc170 nrlc170_2 rlc7 0.001
* RLC[171] rlc0-rlc8
Rrlc171 rlc0 nrlc171_1 16.7266805804
Lrlc171 nrlc171_1 nrlc171_2 1
Crlc171 nrlc171_2 rlc8 3.97134816988e-06
* RLC[172] rlc0-rlc9
Rrlc172 rlc0 nrlc172_1 14.8664275498
Lrlc172 nrlc172_1 nrlc172_2 1
Crlc172 nrlc172_2 rlc9 5.02740940378e-06
* RLC[173] rlc0-rlc10
Rrlc173 rlc0 nrlc173_1 21.707621425
Lrlc173 nrlc173_1 nrlc173_2 0.828585802359
Crlc173 nrlc173_2 rlc10 1.95375678863e-06
* RLC[174] rlc0-rlc11
Rrlc174 rlc0 nrlc174_1 12.8141902752
Lrlc174 nrlc174_1 nrlc174_2 0.000222654371474
Crlc174 nrlc174_2 rlc11 1.50662919883e-09
* RLC[175] rlc0-rlc12
Rrlc175 rlc0 nrlc175_1 1119.5533883
Lrlc175 nrlc175_1 nrlc175_2 1
Crlc175 nrlc175_2 rlc12 8.86477818678e-10
* RLC[176] rlc0-rlc13
Rrlc176 rlc0 nrlc176_1 409.909434747
Lrlc176 nrlc176_1 nrlc176_2 1
Crlc176 nrlc176_2 rlc13 6.61274326224e-09
* RLC[179] rlc0-GND
Rrlc179 rlc0 nrlc179_1 1.05409255339
Lrlc179 nrlc179_1 nrlc179_2 1
Crlc179 nrlc179_2 GND 0.001
* RLC[180] rlc1-rlc2
Rrlc180 rlc1 nrlc180_1 0.874927982653
Lrlc180 nrlc180_1 nrlc180_2 4.98561843484e-09
Crlc180 nrlc180_2 rlc2 7.23655579023e-12
* RLC[182] rlc1-rlc4
Rrlc182 rlc1 nrlc182_1 1937.71865359
Lrlc182 nrlc182_1 nrlc182_2 0.00164994587562
Crlc182 nrlc182_2 rlc4 4.88253930875e-13
* RLC[183] rlc1-rlc5
Rrlc183 rlc1 nrlc183_1 37117.4840199
Lrlc183 nrlc183_1 nrlc183_2 1
Crlc183 nrlc183_2 rlc5 8.06492680309e-13
* RLC[184] rlc1-rlc6
Rrlc184 rlc1 nrlc184_1 72.1105308965
Lrlc184 nrlc184_1 nrlc184_2 1
Crlc184 nrlc184_2 rlc6 2.13678144921e-07
* RLC[185] rlc1-rlc7
Rrlc185 rlc1 nrlc185_1 617.346872768
Lrlc185 nrlc185_1 nrlc185_2 1
Crlc185 nrlc185_2 rlc7 2.91540561247e-09
* RLC[187] rlc1-rlc9
Rrlc187 rlc1 nrlc187_1 8.7832692056
Lrlc187 nrlc187_1 nrlc187_2 0.0115802041872
Crlc187 nrlc187_2 rlc9 1.6678666304e-07
* RLC[188] rlc1-rlc10
Rrlc188 rlc1 nrlc188_1 587.313597317
Lrlc188 nrlc188_1 nrlc188_2 1
Crlc188 nrlc188_2 rlc10 3.22119769253e-09
* RLC[190] rlc1-rlc12
Rrlc190 rlc1 nrlc190_1 1.05409255339
Lrlc190 nrlc190_1 nrlc190_2 1
Crlc190 nrlc190_2 rlc12 0.001
* RLC[191] rlc1-rlc13
Rrlc191 rlc1 nrlc191_1 10088.4670097
Lrlc191 nrlc191_1 nrlc191_2 1
Crlc191 nrlc191_2 rlc13 1.09170961244e-11
* RLC[192] rlc1-rlc14
Rrlc192 rlc1 nrlc192_1 5442.69049699
Lrlc192 nrlc192_1 nrlc192_2 1
Crlc192 nrlc192_2 rlc14 3.75085446414e-11
* RLC[193] rlc1-rlc15
Rrlc193 rlc1 nrlc193_1 349.229575164
Lrlc193 nrlc193_1 nrlc193_2 1
Crlc193 nrlc193_2 rlc15 9.11035833506e-09
* RLC[194] rlc1-GND
Rrlc194 rlc1 nrlc194_1 146.799268531
Lrlc194 nrlc194_1 nrlc194_2 1
Crlc194 nrlc194_2 GND 5.1559619939e-08
* RLC[195] rlc2-rlc3
Rrlc195 rlc2 nrlc195_1 1.05409255339
Lrlc195 nrlc195_1 nrlc195_2 1
Crlc195 nrlc195_2 rlc3 0.001
* RLC[196] rlc2-rlc4
Rrlc196 rlc2 nrlc196_1 6159.43573853
Lrlc196 nrlc196_1 nrlc196_2 1
Crlc196 nrlc196_2 rlc4 2.92870503198e-11
* RLC[197] rlc2-rlc5
Rrlc197 rlc2 nrlc197_1 0.196676912995
Lrlc197 nrlc197_1 nrlc197_2 0.0348136272947
Crlc197 nrlc197_2 rlc5 0.001
* RLC[198] rlc2-rlc6
Rrlc198 rlc2 nrlc198_1 0.574709961673
Lrlc198 nrlc198_1 nrlc198_2 8.39632035239e-07
Crlc198 nrlc198_2 rlc6 2.82454852906e-09
* RLC[199] rlc2-rlc7
Rrlc199 rlc2 nrlc199_1 8.29338494489
Lrlc199 nrlc199_1 nrlc199_2 1
Crlc199 nrlc199_2 rlc7 1.61545119726e-05
* RLC[200] rlc2-rlc8
Rrlc200 rlc2 nrlc200_1 242.613936628
Lrlc200 nrlc200_1 nrlc200_2 1
Crlc200 nrlc200_2 rlc8 1.88766968422e-08
* RLC[201] rlc2-rlc9
Rrlc201 rlc2 nrlc201_1 6164.72947222
Lrlc201 nrlc201_1 nrlc201_2 1
Crlc201 nrlc201_2 rlc9 2.92367735706e-11
* RLC[203] rlc2-rlc11
Rrlc203 rlc2 nrlc203_1 719.366895605
Lrlc203 nrlc203_1 nrlc203_2 1
Crlc203 nrlc203_2 rlc11 2.14712136833e-09
* RLC[204] rlc2-rlc12
Rrlc204 rlc2 nrlc204_1 1.69366013303
Lrlc204 nrlc204_1 nrlc204_2 0.758763789737
Crlc204 nrlc204_2 rlc12 0.000293908101825
* RLC[205] rlc2-rlc13
Rrlc205 rlc2 nrlc205_1 585.035763484
Lrlc205 nrlc205_1 nrlc205_2 0.831125981284
Crlc205 nrlc205_2 rlc13 2.69810917192e-09
* RLC[206] rlc2-rlc14
Rrlc206 rlc2 nrlc206_1 26.0800129097
Lrlc206 nrlc206_1 nrlc206_2 0.000376872797537
Crlc206 nrlc206_2 rlc14 6.15653960935e-10
* RLC[207] rlc2-rlc15
Rrlc207 rlc2 nrlc207_1 0.501367477107
Lrlc207 nrlc207_1 nrlc207_2 1.41755852519e-09
Crlc207 nrlc207_2 rlc15 6.26593912963e-12
* RLC[208] rlc2-GND
Rrlc208 rlc2 nrlc208_1 7.80447144552
Lrlc208 nrlc208_1 nrlc208_2 1
Crlc208 nrlc208_2 GND 1.82419179751e-05
* RLC[209] rlc3-rlc4
Rrlc209 rlc3 nrlc209_1 1.12749271374
Lrlc209 nrlc209_1 nrlc209_2 1
Crlc209 nrlc209_2 rlc4 0.000874037372051
* RLC[210] rlc3-rlc5
Rrlc210 rlc3 nrlc210_1 1118.13927846
Lrlc210 nrlc210_1 nrlc210_2 1
Crlc210 nrlc210_2 rlc5 8.88721492124e-10
* RLC[211] rlc3-rlc6
Rrlc211 rlc3 nrlc211_1 471.056110043
Lrlc211 nrlc211_1 nrlc211_2 1
Crlc211 nrlc211_2 rlc6 5.00739910999e-09
* RLC[212] rlc3-rlc7
Rrlc212 rlc3 nrlc212_1 142.260228386
Lrlc212 nrlc212_1 nrlc212_2 1.10239253019e-06
Crlc212 nrlc212_2 rlc7 6.05238782801e-14
* RLC[213] rlc3-rlc8
Rrlc213 rlc3 nrlc213_1 291.374823892
Lrlc213 nrlc213_1 nrlc213_2 1
Crlc213 nrlc213_2 rlc8 1.30874019949e-08
* RLC[214] rlc3-rlc9
Rrlc214 rlc3 nrlc214_1 10185.3479639
Lrlc214 nrlc214_1 nrlc214_2 1
Crlc214 nrlc214_2 rlc9 1.07104014535e-11
* RLC[215] rlc3-rlc10
Rrlc215 rlc3 nrlc215_1 278.229954583
Lrlc215 nrlc215_1 nrlc215_2 1
Crlc215 nrlc215_2 rlc10 1.43532325344e-08
* RLC[218] rlc3-rlc13
Rrlc218 rlc3 nrlc218_1 1127.43557147
Lrlc218 nrlc218_1 nrlc218_2 1
Crlc218 nrlc218_2 rlc13 8.74125972669e-10
* RLC[220] rlc3-rlc15
Rrlc220 rlc3 nrlc220_1 5.83791002887
Lrlc220 nrlc220_1 nrlc220_2 0.00483375731897
Crlc220 nrlc220_2 rlc15 1.57589594529e-07
* RLC[221] rlc3-GND
Rrlc221 rlc3 nrlc221_1 0.12511219948
Lrlc221 nrlc221_1 nrlc221_2 0.0140877562129
Crlc221 nrlc221_2 GND 0.001
* RLC[223] rlc4-rlc6
Rrlc223 rlc4 nrlc223_1 377.321884062
Lrlc223 nrlc223_1 nrlc223_2 7.80643399371e-12
Crlc223 nrlc223_2 rlc6 4.46313937532e-12
* RLC[224] rlc4-rlc7
Rrlc224 rlc4 nrlc224_1 26.4670026064
Lrlc224 nrlc224_1 nrlc224_2 0.994231226123
Crlc224 nrlc224_2 rlc7 1.57701334819e-06
* RLC[225] rlc4-rlc8
Rrlc225 rlc4 nrlc225_1 15.9480604161
Lrlc225 nrlc225_1 nrlc225_2 1
Crlc225 nrlc225_2 rlc8 4.36859461498e-06
* RLC[226] rlc4-rlc9
Rrlc226 rlc4 nrlc226_1 0.0156195967265
Lrlc226 nrlc226_1 nrlc226_2 0.00021957462171
Crlc226 nrlc226_2 rlc9 0.001
* RLC[228] rlc4-rlc11
Rrlc228 rlc4 nrlc228_1 1124.58042826
Lrlc228 nrlc228_1 nrlc228_2 1
Crlc228 nrlc228_2 rlc11 8.78570159936e-10
* RLC[229] rlc4-rlc12
Rrlc229 rlc4 nrlc229_1 1210.62540337
Lrlc229 nrlc229_1 nrlc229_2 1
Crlc229 nrlc229_2 rlc12 7.58119949546e-10
* RLC[230] rlc4-rlc13
Rrlc230 rlc4 nrlc230_1 38.9190798264
Lrlc230 nrlc230_1 nrlc230_2 0.0395113776804
Crlc230 nrlc230_2 rlc13 2.89837474152e-08
* RLC[231] rlc4-rlc14
Rrlc231 rlc4 nrlc231_1 0.00375074678394
Lrlc231 nrlc231_1 nrlc231_2 4.84521157348e-13
Crlc231 nrlc231_2 rlc14 3.82679101299e-11
* RLC[232] rlc4-rlc15
Rrlc232 rlc4 nrlc232_1 239.934938235
Lrlc232 nrlc232_1 nrlc232_2 1
Crlc232 nrlc232_2 rlc15 1.93005864569e-08
* RLC[234] rlc5-rlc6
Rrlc234 rlc5 nrlc234_1 554.15016862
Lrlc234 nrlc234_1 nrlc234_2 1
Crlc234 nrlc234_2 rlc6 3.61828316168e-09
* RLC[236] rlc5-rlc8
Rrlc236 rlc5 nrlc236_1 5024.45669752
Lrlc236 nrlc236_1 nrlc236_2 1
Crlc236 nrlc236_2 rlc8 4.40128280595e-11
* RLC[237] rlc5-rlc9
Rrlc237 rlc5 nrlc237_1 17.3945846982
Lrlc237 nrlc237_1 nrlc237_2 1
Crlc237 nrlc237_2 rlc9 3.67222566899e-06
* RLC[238] rlc5-rlc10
Rrlc238 rlc5 nrlc238_1 0.00019658664997
Lrlc238 nrlc238_1 nrlc238_2 3.82883644933e-11
Crlc238 nrlc238_2 rlc10 1.10081987576e-06
* RLC[239] rlc5-rlc11
Rrlc239 rlc5 nrlc239_1 201.097696874
Lrlc239 nrlc239_1 nrlc239_2 1
Crlc239 nrlc239_2 rlc11 2.74753540227e-08
* RLC[240] rlc5-rlc12
Rrlc240 rlc5 nrlc240_1 7.2226287607
Lrlc240 nrlc240_1 nrlc240_2 1
Crlc240 nrlc240_2 rlc12 2.1299377199e-05
* RLC[241] rlc5-rlc13
Rrlc241 rlc5 nrlc241_1 79.6125984609
Lrlc241 nrlc241_1 nrlc241_2 0.296614622932
Crlc241 nrlc241_2 rlc13 5.19979773179e-08
* RLC[242] rlc5-rlc14
Rrlc242 rlc5 nrlc242_1 1.41904333836
Lrlc242 nrlc242_1 nrlc242_2 0.814507097506
Crlc242 nrlc242_2 rlc14 0.000449428951043
* RLC[243] rlc5-rlc15
Rrlc243 rlc5 nrlc243_1 6985.55849231
Lrlc243 nrlc243_1 nrlc243_2 1
Crlc243 nrlc243_2 rlc15 2.27695906819e-11
* RLC[244] rlc5-GND
Rrlc244 rlc5 nrlc244_1 26.0210380268
Lrlc244 nrlc244_1 nrlc244_2 1
Crlc244 nrlc244_2 GND 1.64099877107e-06
* RLC[245] rlc6-rlc7
Rrlc245 rlc6 nrlc245_1 19.0180431422
Lrlc245 nrlc245_1 nrlc245_2 1
Crlc245 nrlc245_2 rlc7 3.07203269898e-06
* RLC[247] rlc6-rlc9
Rrlc247 rlc6 nrlc247_1 0.0965645059848
Lrlc247 nrlc247_1 nrlc247_2 7.14632163506e-12
Crlc247 nrlc247_2 rlc9 8.51539901846e-13
* RLC[248] rlc6-rlc10
Rrlc248 rlc6 nrlc248_1 469.052988645
Lrlc248 nrlc248_1 nrlc248_2 0.968684829854
Crlc248 nrlc248_2 rlc10 4.89210955419e-09
* RLC[249] rlc6-rlc11
Rrlc249 rlc6 nrlc249_1 5612.55261117
Lrlc249 nrlc249_1 nrlc249_2 1
Crlc249 nrlc249_2 rlc11 3.5272532353e-11
* RLC[250] rlc6-rlc12
Rrlc250 rlc6 nrlc250_1 6.45601034085
Lrlc250 nrlc250_1 nrlc250_2 4.65050128359e-07
Crlc250 nrlc250_2 rlc12 1.23973489195e-11
* RLC[251] rlc6-rlc13
Rrlc251 rlc6 nrlc251_1 105.934071912
Lrlc251 nrlc251_1 nrlc251_2 0.432330722535
Crlc251 nrlc251_2 rlc13 4.28057644266e-08
* RLC[254] rlc6-GND
Rrlc254 rlc6 nrlc254_1 16.4962667429
Lrlc254 nrlc254_1 nrlc254_2 1
Crlc254 nrlc254_2 GND 4.08306364508e-06
* RLC[255] rlc7-rlc8
Rrlc255 rlc7 nrlc255_1 5905.04349251
Lrlc255 nrlc255_1 nrlc255_2 0.0498585234083
Crlc255 nrlc255_2 rlc8 1.58873221413e-12
* RLC[256] rlc7-rlc9
Rrlc256 rlc7 nrlc256_1 12.2152135426
Lrlc256 nrlc256_1 nrlc256_2 1
Crlc256 nrlc256_2 rlc9 7.44655434609e-06
* RLC[258] rlc7-rlc11
Rrlc258 rlc7 nrlc258_1 1.05409255339
Lrlc258 nrlc258_1 nrlc258_2 1
Crlc258 nrlc258_2 rlc11 0.001
* RLC[259] rlc7-rlc12
Rrlc259 rlc7 nrlc259_1 361.227285345
Lrlc259 nrlc259_1 nrlc259_2 1
Crlc259 nrlc259_2 rlc12 8.51523025283e-09
* RLC[260] rlc7-rlc13
Rrlc260 rlc7 nrlc260_1 1.05409255339
Lrlc260 nrlc260_1 nrlc260_2 1
Crlc260 nrlc260_2 rlc13 0.001
* RLC[261] rlc7-rlc14
Rrlc261 rlc7 nrlc261_1 1.17792655249
Lrlc261 nrlc261_1 nrlc261_2 1
Crlc261 nrlc261_2 rlc14 0.000800794473475
* RLC[262] rlc7-rlc15
Rrlc262 rlc7 nrlc262_1 1.05409255339
Lrlc262 nrlc262_1 nrlc262_2 1
Crlc262 nrlc262_2 rlc15 0.001
* RLC[263] rlc7-GND
Rrlc263 rlc7 nrlc263_1 1.05409255339
Lrlc263 nrlc263_1 nrlc263_2 1
Crlc263 nrlc263_2 GND 0.001
* RLC[264] rlc8-rlc9
Rrlc264 rlc8 nrlc264_1 11.7194390812
Lrlc264 nrlc264_1 nrlc264_2 1
Crlc264 nrlc264_2 rlc9 8.08991276995e-06
* RLC[265] rlc8-rlc10
Rrlc265 rlc8 nrlc265_1 1.05409255339
Lrlc265 nrlc265_1 nrlc265_2 1
Crlc265 nrlc265_2 rlc10 0.001
* RLC[266] rlc8-rlc11
Rrlc266 rlc8 nrlc266_1 65.2711979441
Lrlc266 nrlc266_1 nrlc266_2 1
Crlc266 nrlc266_2 rlc11 2.60804045371e-07
* RLC[267] rlc8-rlc12
Rrlc267 rlc8 nrlc267_1 1292.49732924
Lrlc267 nrlc267_1 nrlc267_2 1
Crlc267 nrlc267_2 rlc12 6.65117204539e-10
* RLC[268] rlc8-rlc13
Rrlc268 rlc8 nrlc268_1 1309.78407899
Lrlc268 nrlc268_1 nrlc268_2 1
Crlc268 nrlc268_2 rlc13 6.47676405749e-10
* RLC[269] rlc8-rlc14
Rrlc269 rlc8 nrlc269_1 3.0495048127
Lrlc269 nrlc269_1 nrlc269_2 1
Crlc269 nrlc269_2 rlc14 0.000119480998785
* RLC[270] rlc8-rlc15
Rrlc270 rlc8 nrlc270_1 52384.3320628
Lrlc270 nrlc270_1 nrlc270_2 0.00973128133023
Crlc270 nrlc270_2 rlc15 5.83034952978e-13
* RLC[271] rlc8-GND
Rrlc271 rlc8 nrlc271_1 21.1513316585
Lrlc271 nrlc271_1 nrlc271_2 1
Crlc271 nrlc271_2 GND 2.48360233944e-06
* RLC[272] rlc9-rlc10
Rrlc272 rlc9 nrlc272_1 12.0209665037
Lrlc272 nrlc272_1 nrlc272_2 1
Crlc272 nrlc272_2 rlc10 7.68915678738e-06
* RLC[275] rlc9-rlc13
Rrlc275 rlc9 nrlc275_1 0.15531586522
Lrlc275 nrlc275_1 nrlc275_2 1.28495798974e-11
Crlc275 nrlc275_2 rlc13 5.91854261499e-13
* RLC[276] rlc9-rlc14
Rrlc276 rlc9 nrlc276_1 381.796382479
Lrlc276 nrlc276_1 nrlc276_2 0.171751020654
Crlc276 nrlc276_2 rlc14 1.30916142117e-09
* RLC[277] rlc9-rlc15
Rrlc277 rlc9 nrlc277_1 488.105020435
Lrlc277 nrlc277_1 nrlc277_2 1
Crlc277 nrlc277_2 rlc15 4.66370360082e-09
* RLC[278] rlc9-GND
Rrlc278 rlc9 nrlc278_1 707.290759689
Lrlc278 nrlc278_1 nrlc278_2 1
Crlc278 nrlc278_2 GND 2.22106629607e-09
* RLC[279] rlc10-rlc11
Rrlc279 rlc10 nrlc279_1 8.38276836845
Lrlc279 nrlc279_1 nrlc279_2 1
Crlc279 nrlc279_2 rlc11 1.58118453731e-05
* RLC[280] rlc10-rlc12
Rrlc280 rlc10 nrlc280_1 0.833286420056
Lrlc280 nrlc280_1 nrlc280_2 0.624929632064
Crlc280 nrlc280_2 rlc12 0.001
* RLC[281] rlc10-rlc13
Rrlc281 rlc10 nrlc281_1 0.0741608755027
Lrlc281 nrlc281_1 nrlc281_2 2.19173879636e-10
Crlc281 nrlc281_2 rlc13 4.42788761423e-11
* RLC[282] rlc10-rlc14
Rrlc282 rlc10 nrlc282_1 4.15788741915
Lrlc282 nrlc282_1 nrlc282_2 1
Crlc282 nrlc282_2 rlc14 6.42705532745e-05
* RLC[283] rlc10-rlc15
Rrlc283 rlc10 nrlc283_1 6985.54825561
Lrlc283 nrlc283_1 nrlc283_2 1
Crlc283 nrlc283_2 rlc15 2.27696574156e-11
* RLC[284] rlc10-GND
Rrlc284 rlc10 nrlc284_1 40.904240863
Lrlc284 nrlc284_1 nrlc284_2 1
Crlc284 nrlc284_2 GND 6.64080635501e-07
* RLC[285] rlc11-rlc12
Rrlc285 rlc11 nrlc285_1 6545.83874734
Lrlc285 nrlc285_1 nrlc285_2 1
Crlc285 nrlc285_2 rlc12 2.59314550011e-11
* RLC[286] rlc11-rlc13
Rrlc286 rlc11 nrlc286_1 50.0048691225
Lrlc286 nrlc286_1 nrlc286_2 1
Crlc286 nrlc286_2 rlc13 4.44357894909e-07
* RLC[287] rlc11-rlc14
Rrlc287 rlc11 nrlc287_1 827.202603571
Lrlc287 nrlc287_1 nrlc287_2 1
Crlc287 nrlc287_2 rlc14 1.62380436767e-09
* RLC[288] rlc11-rlc15
Rrlc288 rlc11 nrlc288_1 0.00485379982484
Lrlc288 nrlc288_1 nrlc288_2 1.90364714111e-08
Crlc288 nrlc288_2 rlc15 8.9780127574e-07
* RLC[289] rlc11-GND
Rrlc289 rlc11 nrlc289_1 0.0389923120758
Lrlc289 nrlc289_1 nrlc289_2 1.20917130818e-05
Crlc289 nrlc289_2 GND 8.83664378712e-06
* RLC[290] rlc12-rlc13
Rrlc290 rlc12 nrlc290_1 6037.28547773
Lrlc290 nrlc290_1 nrlc290_2 1
Crlc290 nrlc290_2 rlc13 3.04841483178e-11
* RLC[292] rlc12-rlc15
Rrlc292 rlc12 nrlc292_1 636.287537173
Lrlc292 nrlc292_1 nrlc292_2 1
Crlc292 nrlc292_2 rlc15 2.74442051308e-09
* RLC[293] rlc12-GND
Rrlc293 rlc12 nrlc293_1 0.113557449554
Lrlc293 nrlc293_1 nrlc293_2 1.94810403379e-09
Crlc293 nrlc293_2 GND 1.67856582325e-10
* RLC[294] rlc13-rlc14
Rrlc294 rlc13 nrlc294_1 75.7005585813
Lrlc294 nrlc294_1 nrlc294_2 0.197391917658
Crlc294 nrlc294_2 rlc14 3.82726636382e-08
* RLC[296] rlc13-GND
Rrlc296 rlc13 nrlc296_1 557643.035825
Lrlc296 nrlc296_1 nrlc296_2 1
Crlc296 nrlc296_2 GND 3.57309797559e-15
* RLC[297] rlc14-rlc15
Rrlc297 rlc14 nrlc297_1 1.23695229951
Lrlc297 nrlc297_1 nrlc297_2 9.24224215266e-08
Crlc297 nrlc297_2 rlc15 6.71164425633e-11
* RLC[298] rlc14-GND
Rrlc298 rlc14 nrlc298_1 828.62674648
Lrlc298 nrlc298_1 nrlc298_2 1
Crlc298 nrlc298_2 GND 1.61822756909e-09
* RLC[299] rlc15-GND
Rrlc299 rlc15 nrlc299_1 0.0001
Lrlc299 nrlc299_1 nrlc299_2 1.27187113648e-14
Crlc299 nrlc299_2 GND 4.3966879307e-08
* DC[0] P1A-P2A
Rdc0 P1A ndc0_1 0.0859062991295
Ldc0 ndc0_1 P2A 1.5580364105e-07
* DC[1] P1A-P3A
Rdc1 P1A ndc1_1 771613506128
Ldc1 ndc1_1 P3A 1
* DC[2] P1A-P4A
Rdc2 P1A ndc2_1 771749491928
Ldc2 ndc2_1 P4A 1
* DC[3] P1A-P1B
Rdc3 P1A ndc3_1 2.55041785122e+13
Ldc3 ndc3_1 P1B 1
* DC[7] P1A-dc0
Rdc7 P1A ndc7_1 2.50774447254e+13
Ldc7 ndc7_1 dc0 1
* DC[8] P1A-dc1
Rdc8 P1A ndc8_1 2.47712904835e+13
Ldc8 ndc8_1 dc1 1
* DC[9] P1A-dc2
Rdc9 P1A ndc9_1 2.44452331024e+13
Ldc9 ndc9_1 dc2 1
* DC[10] P1A-dc3
Rdc10 P1A ndc10_1 2.43585177935e+13
Ldc10 ndc10_1 dc3 1
* DC[12] P2A-P3A
Rdc12 P2A ndc12_1 771428579147
Ldc12 ndc12_1 P3A 1
* DC[13] P2A-P4A
Rdc13 P2A ndc13_1 777474017597
Ldc13 ndc13_1 P4A 1
* DC[14] P2A-P1B
Rdc14 P2A ndc14_1 2.49905400271e+13
Ldc14 ndc14_1 P1B 1
* DC[16] P2A-P3B
Rdc16 P2A ndc16_1 2.38453185841e+13
Ldc16 ndc16_1 P3B 1
* DC[17] P2A-P4B
Rdc17 P2A ndc17_1 2.32655165447e+13
Ldc17 ndc17_1 P4B 1
* DC[18] P2A-dc0
Rdc18 P2A ndc18_1 2.38169425091e+13
Ldc18 ndc18_1 dc0 1
* DC[19] P2A-dc1
Rdc19 P2A ndc19_1 2.39065617782e+13
Ldc19 ndc19_1 dc1 1
* DC[20] P2A-dc2
Rdc20 P2A ndc20_1 2.46543960234e+13
Ldc20 ndc20_1 dc2 1
* DC[21] P2A-dc3
Rdc21 P2A ndc21_1 2.48248100754e+13
Ldc21 ndc21_1 dc3 1
* DC[23] P3A-P4A
Rdc23 P3A ndc23_1 0.129900574892
Ldc23 ndc23_1 P4A 1.82243205678e-07
* DC[33] P4A-P1B
Rdc33 P4A ndc33_1 1e+15
Ldc33 ndc33_1 P1B 1
* DC[38] P4A-dc1
Rdc38 P4A ndc38_1 1e+15
Ldc38 ndc38_1 dc1 1
* DC[39] P4A-dc2
Rdc39 P4A ndc39_1 1e+15
Ldc39 ndc39_1 dc2 1
* DC[42] P1B-P2B
Rdc42 P1B ndc42_1 0.132305673405
Ldc42 ndc42_1 P2B 1.18287000664e-07
* DC[43] P1B-P3B
Rdc43 P1B ndc43_1 0.000646458856167
Ldc43 ndc43_1 P3B 4.29928917459e-09
* DC[46] P1B-dc1
Rdc46 P1B ndc46_1 0.00245569063344
Ldc46 ndc46_1 dc1 3.90835303016e-10
* DC[47] P1B-dc2
Rdc47 P1B ndc47_1 0.00106544519125
Ldc47 ndc47_1 dc2 6.45277643037e-07
* DC[48] P1B-dc3
Rdc48 P1B ndc48_1 0.0726636650607
Ldc48 ndc48_1 dc3 8.46616404686e-07
* DC[50] P2B-P3B
Rdc50 P2B ndc50_1 0.00499845598516
Ldc50 ndc50_1 P3B 8.08806053812e-07
* DC[51] P2B-P4B
Rdc51 P2B ndc51_1 0.000745560312079
Ldc51 ndc51_1 P4B 3.38156853399e-09
* DC[54] P2B-dc2
Rdc54 P2B ndc54_1 0.006236093989
Ldc54 ndc54_1 dc2 9.98854954244e-10
* DC[57] P3B-P4B
Rdc57 P3B ndc57_1 0.416844757618
Ldc57 ndc57_1 P4B 3.7166192104e-07
* DC[58] P3B-dc0
Rdc58 P3B ndc58_1 0.00791686462286
Ldc58 ndc58_1 dc0 1.26000813852e-09
* DC[59] P3B-dc1
Rdc59 P3B ndc59_1 0.00561855991939
Ldc59 ndc59_1 dc1 8.00469938034e-08
* DC[61] P3B-dc3
Rdc61 P3B ndc61_1 0.0104048625115
Ldc61 ndc61_1 dc3 1.6559853009e-09
* DC[63] P4B-dc0
Rdc63 P4B ndc63_1 0.0001
Ldc63 ndc63_1 dc0 3.13404563272e-08
* DC[70] dc0-dc3
Rdc70 dc0 ndc70_1 0.0001
Ldc70 ndc70_1 dc3 2.9696766207e-08
* DC[73] dc1-dc3
Rdc73 dc1 ndc73_1 0.00156050809741
Ldc73 ndc73_1 dc3 6.0935804169e-08
* ---- leaks
Rleak_P1A P1A GND 1e+12
Rleak_P1B P1B GND 1e+12
Rleak_P2A P2A GND 1e+12
Rleak_P2B P2B GND 1e+12
Rleak_P3A P3A GND 1e+12
Rleak_P3B P3B GND 1e+12
Rleak_P4A P4A GND 1e+12
Rleak_P4B P4B GND 1e+12
Rleak_dc0 dc0 GND 1e+12
Rleak_dc1 dc1 GND 1e+12
Rleak_dc2 dc2 GND 1e+12
Rleak_dc3 dc3 GND 1e+12
Rleak_rlc0 rlc0 GND 1e+12
Rleak_rlc1 rlc1 GND 1e+12
Rleak_rlc10 rlc10 GND 1e+12
Rleak_rlc11 rlc11 GND 1e+12
Rleak_rlc12 rlc12 GND 1e+12
Rleak_rlc13 rlc13 GND 1e+12
Rleak_rlc14 rlc14 GND 1e+12
Rleak_rlc15 rlc15 GND 1e+12
Rleak_rlc2 rlc2 GND 1e+12
Rleak_rlc3 rlc3 GND 1e+12
Rleak_rlc4 rlc4 GND 1e+12
Rleak_rlc5 rlc5 GND 1e+12
Rleak_rlc6 rlc6 GND 1e+12
Rleak_rlc7 rlc7 GND 1e+12
Rleak_rlc8 rlc8 GND 1e+12
Rleak_rlc9 rlc9 GND 1e+12
.ends fitted
