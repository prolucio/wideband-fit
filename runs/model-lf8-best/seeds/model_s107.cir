* fitted: 8-port fitted model, reference z0 = 50 Ohm
* every pin is a port against GND
.subckt fitted P1A P1B P2A P2B P3A P3B P4A P4B GND
* ---- branches
* RLC[1] P1A-P3A
Rrlc1 P1A nrlc1_1 6.25610705389e+12
Lrlc1 nrlc1_1 nrlc1_2 0.00173572677194
Crlc1 nrlc1_2 P3A 4.72199796781e-10
* RLC[2] P1A-P4A
Rrlc2 P1A nrlc2_1 6.12256513072e+12
Lrlc2 nrlc2_1 nrlc2_2 0.975448622168
Crlc2 nrlc2_2 P4A 1.17345644701e-05
* RLC[3] P1A-P1B
Rrlc3 P1A nrlc3_1 11986.644473
Lrlc3 nrlc3_1 nrlc3_2 8.32136397019e-07
Crlc3 nrlc3_2 P1B 4.05011257477e-12
* RLC[4] P1A-P2B
Rrlc4 P1A nrlc4_1 1359.49065314
Lrlc4 nrlc4_1 nrlc4_2 0.0100254579105
Crlc4 nrlc4_2 P2B 6.02711192526e-12
* RLC[7] P1A-rlc0
Rrlc7 P1A nrlc7_1 628.692493874
Lrlc7 nrlc7_1 nrlc7_2 1.79576368359e-07
Crlc7 nrlc7_2 rlc0 2.7867893854e-12
* RLC[9] P1A-rlc2
Rrlc9 P1A nrlc9_1 14584.5683507
Lrlc9 nrlc9_1 nrlc9_2 1
Crlc9 nrlc9_2 rlc2 5.22360501657e-12
* RLC[10] P1A-rlc3
Rrlc10 P1A nrlc10_1 8327.85834278
Lrlc10 nrlc10_1 nrlc10_2 1
Crlc10 nrlc10_2 rlc3 1.6021044701e-11
* RLC[11] P1A-rlc4
Rrlc11 P1A nrlc11_1 2183.60393835
Lrlc11 nrlc11_1 nrlc11_2 1
Crlc11 nrlc11_2 rlc4 2.33028882611e-10
* RLC[20] P1A-rlc13
Rrlc20 P1A nrlc20_1 2087.50544727
Lrlc20 nrlc20_1 nrlc20_2 1
Crlc20 nrlc20_2 rlc13 2.54977733112e-10
* RLC[23] P1A-GND
Rrlc23 P1A nrlc23_1 15734.6953273
Lrlc23 nrlc23_1 nrlc23_2 0.1669957505
Crlc23 nrlc23_2 GND 7.49456161456e-13
* RLC[25] P2A-P4A
Rrlc25 P2A nrlc25_1 9.9910653695e+12
Lrlc25 nrlc25_1 nrlc25_2 0.724130238673
Crlc25 nrlc25_2 P4A 2.34382769567e-10
* RLC[28] P2A-P3B
Rrlc28 P2A nrlc28_1 12.5140818436
Lrlc28 nrlc28_1 nrlc28_2 3.21685605942e-07
Crlc28 nrlc28_2 P3B 9.09926444887e-12
* RLC[29] P2A-P4B
Rrlc29 P2A nrlc29_1 6081.57897995
Lrlc29 nrlc29_1 nrlc29_2 0.00231637834724
Crlc29 nrlc29_2 P4B 4.26746652823e-12
* RLC[30] P2A-rlc0
Rrlc30 P2A nrlc30_1 1326.92071785
Lrlc30 nrlc30_1 nrlc30_2 1
Crlc30 nrlc30_2 rlc0 6.31055477289e-10
* RLC[34] P2A-rlc4
Rrlc34 P2A nrlc34_1 75870.5628329
Lrlc34 nrlc34_1 nrlc34_2 1
Crlc34 nrlc34_2 rlc4 1.93023807884e-13
* RLC[37] P2A-rlc7
Rrlc37 P2A nrlc37_1 1440.7350598
Lrlc37 nrlc37_1 nrlc37_2 1
Crlc37 nrlc37_2 rlc7 5.35290136733e-10
* RLC[39] P2A-rlc9
Rrlc39 P2A nrlc39_1 408.795165966
Lrlc39 nrlc39_1 nrlc39_2 1
Crlc39 nrlc39_2 rlc9 6.64884161231e-09
* RLC[44] P2A-rlc14
Rrlc44 P2A nrlc44_1 374.076510751
Lrlc44 nrlc44_1 nrlc44_2 1
Crlc44 nrlc44_2 rlc14 7.94029455547e-09
* RLC[50] P3A-P3B
Rrlc50 P3A nrlc50_1 1380.0860973
Lrlc50 nrlc50_1 nrlc50_2 0.00993996203845
Crlc50 nrlc50_2 P3B 5.79868950209e-12
* RLC[51] P3A-P4B
Rrlc51 P3A nrlc51_1 28771.2244845
Lrlc51 nrlc51_1 nrlc51_2 1
Crlc51 nrlc51_2 P4B 1.34227283011e-12
* RLC[52] P3A-rlc0
Rrlc52 P3A nrlc52_1 4257.11485394
Lrlc52 nrlc52_1 nrlc52_2 1
Crlc52 nrlc52_2 rlc0 6.130935624e-11
* RLC[54] P3A-rlc2
Rrlc54 P3A nrlc54_1 1295.36330264
Lrlc54 nrlc54_1 nrlc54_2 1
Crlc54 nrlc54_2 rlc2 6.62177335106e-10
* RLC[55] P3A-rlc3
Rrlc55 P3A nrlc55_1 812.862730603
Lrlc55 nrlc55_1 nrlc55_2 1
Crlc55 nrlc55_2 rlc3 1.68160142598e-09
* RLC[57] P3A-rlc5
Rrlc57 P3A nrlc57_1 3.43476168084
Lrlc57 nrlc57_1 nrlc57_2 3.32922603811e-08
Crlc57 nrlc57_2 rlc5 3.13550541327e-12
* RLC[61] P3A-rlc9
Rrlc61 P3A nrlc61_1 732.594113561
Lrlc61 nrlc61_1 nrlc61_2 1
Crlc61 nrlc61_2 rlc9 2.07028740988e-09
* RLC[62] P3A-rlc10
Rrlc62 P3A nrlc62_1 31355.6678755
Lrlc62 nrlc62_1 nrlc62_2 0.011121998141
Crlc62 nrlc62_2 rlc10 1.2569216225e-14
* RLC[64] P3A-rlc12
Rrlc64 P3A nrlc64_1 13859.4531008
Lrlc64 nrlc64_1 nrlc64_2 1
Crlc64 nrlc64_2 rlc12 5.7844930576e-12
* RLC[66] P3A-rlc14
Rrlc66 P3A nrlc66_1 8600.36877232
Lrlc66 nrlc66_1 nrlc66_2 0.251519834614
Crlc66 nrlc66_2 rlc14 3.77829255165e-12
* RLC[70] P4A-P2B
Rrlc70 P4A nrlc70_1 19618.9263776
Lrlc70 nrlc70_1 nrlc70_2 1
Crlc70 nrlc70_2 P2B 2.88673565042e-12
* RLC[72] P4A-P4B
Rrlc72 P4A nrlc72_1 2770.55365759
Lrlc72 nrlc72_1 nrlc72_2 0.00146199004197
Crlc72 nrlc72_2 P4B 9.67602969827e-12
* RLC[73] P4A-rlc0
Rrlc73 P4A nrlc73_1 349.591153175
Lrlc73 nrlc73_1 nrlc73_2 1.37703355655e-14
Crlc73 nrlc73_2 rlc0 1.97259865268e-11
* RLC[76] P4A-rlc3
Rrlc76 P4A nrlc76_1 19765.9000448
Lrlc76 nrlc76_1 nrlc76_2 6.07541986218e-06
Crlc76 nrlc76_2 rlc3 6.78122817015e-15
* RLC[84] P4A-rlc11
Rrlc84 P4A nrlc84_1 638.50448841
Lrlc84 nrlc84_1 nrlc84_2 1
Crlc84 nrlc84_2 rlc11 2.72539579514e-09
* RLC[93] P1B-rlc0
Rrlc93 P1B nrlc93_1 0.818174971132
Lrlc93 nrlc93_1 nrlc93_2 1.24045323632e-07
Crlc93 nrlc93_2 rlc0 2.05894861177e-10
* RLC[99] P1B-rlc6
Rrlc99 P1B nrlc99_1 1.05409255339
Lrlc99 nrlc99_1 nrlc99_2 1
Crlc99 nrlc99_2 rlc6 0.001
* RLC[115] P2B-rlc3
Rrlc115 P2B nrlc115_1 28.8709990017
Lrlc115 nrlc115_1 nrlc115_2 4.99429253287e-08
Crlc115 nrlc115_2 rlc3 6.6574489364e-14
* RLC[117] P2B-rlc5
Rrlc117 P2B nrlc117_1 356.083392114
Lrlc117 nrlc117_1 nrlc117_2 1
Crlc117 nrlc117_2 rlc5 8.76302505946e-09
* RLC[119] P2B-rlc7
Rrlc119 P2B nrlc119_1 2525.92638444
Lrlc119 nrlc119_1 nrlc119_2 1
Crlc119 nrlc119_2 rlc7 1.74147045934e-10
* RLC[121] P2B-rlc9
Rrlc121 P2B nrlc121_1 19.1969364983
Lrlc121 nrlc121_1 nrlc121_2 1
Crlc121 nrlc121_2 rlc9 3.01504385836e-06
* RLC[123] P2B-rlc11
Rrlc123 P2B nrlc123_1 14.8540194464
Lrlc123 nrlc123_1 nrlc123_2 1
Crlc123 nrlc123_2 rlc11 5.03581206817e-06
* RLC[125] P2B-rlc13
Rrlc125 P2B nrlc125_1 26.9243403352
Lrlc125 nrlc125_1 nrlc125_2 1
Crlc125 nrlc125_2 rlc13 1.53273596262e-06
* RLC[126] P2B-rlc14
Rrlc126 P2B nrlc126_1 10499.3626456
Lrlc126 nrlc126_1 nrlc126_2 1
Crlc126 nrlc126_2 rlc14 1.0079328918e-11
* RLC[130] P3B-rlc0
Rrlc130 P3B nrlc130_1 426.186587399
Lrlc130 nrlc130_1 nrlc130_2 0.978481314539
Crlc130 nrlc130_2 rlc0 5.98563832427e-09
* RLC[131] P3B-rlc1
Rrlc131 P3B nrlc131_1 226963.68002
Lrlc131 nrlc131_1 nrlc131_2 1
Crlc131 nrlc131_2 rlc1 2.15697326131e-14
* RLC[133] P3B-rlc3
Rrlc133 P3B nrlc133_1 27111.4702227
Lrlc133 nrlc133_1 nrlc133_2 1
Crlc133 nrlc133_2 rlc3 1.51165035914e-12
* RLC[136] P3B-rlc6
Rrlc136 P3B nrlc136_1 4.61336225453
Lrlc136 nrlc136_1 nrlc136_2 1
Crlc136 nrlc136_2 rlc6 5.22062350702e-05
* RLC[144] P3B-rlc14
Rrlc144 P3B nrlc144_1 45.1175938029
Lrlc144 nrlc144_1 nrlc144_2 1
Crlc144 nrlc144_2 rlc14 5.45840342379e-07
* RLC[145] P3B-rlc15
Rrlc145 P3B nrlc145_1 480.658250054
Lrlc145 nrlc145_1 nrlc145_2 5.6976267076e-05
Crlc145 nrlc145_2 rlc15 2.74017740377e-13
* RLC[147] P4B-rlc0
Rrlc147 P4B nrlc147_1 145.082095689
Lrlc147 nrlc147_1 nrlc147_2 2.70951232411e-15
Crlc147 nrlc147_2 rlc0 1.0953107396e-11
* RLC[151] P4B-rlc4
Rrlc151 P4B nrlc151_1 20929.8835084
Lrlc151 nrlc151_1 nrlc151_2 1
Crlc151 nrlc151_2 rlc4 2.53643576465e-12
* RLC[154] P4B-rlc7
Rrlc154 P4B nrlc154_1 638.415825786
Lrlc154 nrlc154_1 nrlc154_2 1
Crlc154 nrlc154_2 rlc7 2.72615284882e-09
* RLC[155] P4B-rlc8
Rrlc155 P4B nrlc155_1 38.4524673292
Lrlc155 nrlc155_1 nrlc155_2 1
Crlc155 nrlc155_2 rlc8 7.51465534762e-07
* RLC[159] P4B-rlc12
Rrlc159 P4B nrlc159_1 34381.4576248
Lrlc159 nrlc159_1 nrlc159_2 0.0195160438169
Crlc159 nrlc159_2 rlc12 1.83442814574e-14
* RLC[164] rlc0-rlc1
Rrlc164 rlc0 nrlc164_1 16.7880803649
Lrlc164 nrlc164_1 nrlc164_2 1
Crlc164 nrlc164_2 rlc1 3.9423521187e-06
* RLC[166] rlc0-rlc3
Rrlc166 rlc0 nrlc166_1 6.75385189248
Lrlc166 nrlc166_1 nrlc166_2 1
Crlc166 nrlc166_2 rlc3 2.43587178713e-05
* RLC[169] rlc0-rlc6
Rrlc169 rlc0 nrlc169_1 0.00813484788129
Lrlc169 nrlc169_1 nrlc169_2 1.10245492016e-15
Crlc169 nrlc169_2 rlc6 5.85647940263e-12
* RLC[170] rlc0-rlc7
Rrlc170 rlc0 nrlc170_1 925.753598965
Lrlc170 nrlc170_1 nrlc170_2 0.00368877025159
Crlc170 nrlc170_2 rlc7 4.78242622492e-12
* RLC[171] rlc0-rlc8
Rrlc171 rlc0 nrlc171_1 36.0180628851
Lrlc171 nrlc171_1 nrlc171_2 1
Crlc171 nrlc171_2 rlc8 8.5647913334e-07
* RLC[172] rlc0-rlc9
Rrlc172 rlc0 nrlc172_1 43.1874406887
Lrlc172 nrlc172_1 nrlc172_2 1
Crlc172 nrlc172_2 rlc9 5.95720511867e-07
* RLC[174] rlc0-rlc11
Rrlc174 rlc0 nrlc174_1 652.014021519
Lrlc174 nrlc174_1 nrlc174_2 1
Crlc174 nrlc174_2 rlc11 2.61362707216e-09
* RLC[175] rlc0-rlc12
Rrlc175 rlc0 nrlc175_1 501.89759492
Lrlc175 nrlc175_1 nrlc175_2 1
Crlc175 nrlc175_2 rlc12 4.41090050264e-09
* RLC[176] rlc0-rlc13
Rrlc176 rlc0 nrlc176_1 20.6263102157
Lrlc176 nrlc176_1 nrlc176_2 1
Crlc176 nrlc176_2 rlc13 2.61164654613e-06
* RLC[178] rlc0-rlc15
Rrlc178 rlc0 nrlc178_1 4026.30413569
Lrlc178 nrlc178_1 nrlc178_2 0.00140544234058
Crlc178 nrlc178_2 rlc15 9.63290703957e-14
* RLC[179] rlc0-GND
Rrlc179 rlc0 nrlc179_1 3.22522256395
Lrlc179 nrlc179_1 nrlc179_2 1
Crlc179 nrlc179_2 GND 0.000106816442936
* RLC[182] rlc1-rlc4
Rrlc182 rlc1 nrlc182_1 5.02466483624
Lrlc182 nrlc182_1 nrlc182_2 0.441782678803
Crlc182 nrlc182_2 rlc4 1.94424942331e-05
* RLC[183] rlc1-rlc5
Rrlc183 rlc1 nrlc183_1 20.756829799
Lrlc183 nrlc183_1 nrlc183_2 0.0664612508516
Crlc183 nrlc183_2 rlc5 1.71397290775e-07
* RLC[185] rlc1-rlc7
Rrlc185 rlc1 nrlc185_1 56768.2741292
Lrlc185 nrlc185_1 nrlc185_2 0.0744809444022
Crlc185 nrlc185_2 rlc7 2.56797790868e-14
* RLC[186] rlc1-rlc8
Rrlc186 rlc1 nrlc186_1 8613.00072531
Lrlc186 nrlc186_1 nrlc186_2 1
Crlc186 nrlc186_2 rlc8 1.49778171014e-11
* RLC[188] rlc1-rlc10
Rrlc188 rlc1 nrlc188_1 358.229433368
Lrlc188 nrlc188_1 nrlc188_2 3.50129779847e-05
Crlc188 nrlc188_2 rlc10 3.03154492872e-13
* RLC[189] rlc1-rlc11
Rrlc189 rlc1 nrlc189_1 12.2960072062
Lrlc189 nrlc189_1 nrlc189_2 1
Crlc189 nrlc189_2 rlc11 7.34901734738e-06
* RLC[190] rlc1-rlc12
Rrlc190 rlc1 nrlc190_1 138.276969489
Lrlc190 nrlc190_1 nrlc190_2 0.00106005554114
Crlc190 nrlc190_2 rlc12 6.16008075216e-11
* RLC[191] rlc1-rlc13
Rrlc191 rlc1 nrlc191_1 32372.059285
Lrlc191 nrlc191_1 nrlc191_2 1
Crlc191 nrlc191_2 rlc13 0.001
* RLC[192] rlc1-rlc14
Rrlc192 rlc1 nrlc192_1 21725.7219444
Lrlc192 nrlc192_1 nrlc192_2 1
Crlc192 nrlc192_2 rlc14 2.35401408288e-12
* RLC[193] rlc1-rlc15
Rrlc193 rlc1 nrlc193_1 719.076984901
Lrlc193 nrlc193_1 nrlc193_2 1
Crlc193 nrlc193_2 rlc15 2.14885302979e-09
* RLC[194] rlc1-GND
Rrlc194 rlc1 nrlc194_1 330.917607726
Lrlc194 nrlc194_1 nrlc194_2 1
Crlc194 nrlc194_2 GND 1.01465345481e-08
* RLC[195] rlc2-rlc3
Rrlc195 rlc2 nrlc195_1 1.05409255339
Lrlc195 nrlc195_1 nrlc195_2 1
Crlc195 nrlc195_2 rlc3 0.001
* RLC[196] rlc2-rlc4
Rrlc196 rlc2 nrlc196_1 1.05409255339
Lrlc196 nrlc196_1 nrlc196_2 1
Crlc196 nrlc196_2 rlc4 0.001
* RLC[197] rlc2-rlc5
Rrlc197 rlc2 nrlc197_1 1082.63902896
Lrlc197 nrlc197_1 nrlc197_2 0.962242453773
Crlc197 nrlc197_2 rlc5 9.12167607895e-10
* RLC[198] rlc2-rlc6
Rrlc198 rlc2 nrlc198_1 27.0388684147
Lrlc198 nrlc198_1 nrlc198_2 1
Crlc198 nrlc198_2 rlc6 1.51977909366e-06
* RLC[199] rlc2-rlc7
Rrlc199 rlc2 nrlc199_1 61059.7488384
Lrlc199 nrlc199_1 nrlc199_2 1
Crlc199 nrlc199_2 rlc7 2.98021408861e-13
* RLC[200] rlc2-rlc8
Rrlc200 rlc2 nrlc200_1 1767.68355802
Lrlc200 nrlc200_1 nrlc200_2 1
Crlc200 nrlc200_2 rlc8 3.55589104814e-10
* RLC[202] rlc2-rlc10
Rrlc202 rlc2 nrlc202_1 49.5745158307
Lrlc202 nrlc202_1 nrlc202_2 1
Crlc202 nrlc202_2 rlc10 4.52106267688e-07
* RLC[205] rlc2-rlc13
Rrlc205 rlc2 nrlc205_1 24.6558457962
Lrlc205 nrlc205_1 nrlc205_2 1
Crlc205 nrlc205_2 rlc13 1.82775373548e-06
* RLC[206] rlc2-rlc14
Rrlc206 rlc2 nrlc206_1 13.457920135
Lrlc206 nrlc206_1 nrlc206_2 1
Crlc206 nrlc206_2 rlc14 6.13481678562e-06
* RLC[208] rlc2-GND
Rrlc208 rlc2 nrlc208_1 2.54987389403
Lrlc208 nrlc208_1 nrlc208_2 1
Crlc208 nrlc208_2 GND 0.00017089135187
* RLC[209] rlc3-rlc4
Rrlc209 rlc3 nrlc209_1 2004.20534036
Lrlc209 nrlc209_1 nrlc209_2 0.931564338284
Crlc209 nrlc209_2 rlc4 2.57683087384e-10
* RLC[210] rlc3-rlc5
Rrlc210 rlc3 nrlc210_1 0.633727530486
Lrlc210 nrlc210_1 nrlc210_2 0.361449524607
Crlc210 nrlc210_2 rlc5 0.001
* RLC[211] rlc3-rlc6
Rrlc211 rlc3 nrlc211_1 409290.553245
Lrlc211 nrlc211_1 nrlc211_2 1
Crlc211 nrlc211_2 rlc6 6.63275642185e-15
* RLC[212] rlc3-rlc7
Rrlc212 rlc3 nrlc212_1 1.05409255339
Lrlc212 nrlc212_1 nrlc212_2 1
Crlc212 nrlc212_2 rlc7 0.001
* RLC[213] rlc3-rlc8
Rrlc213 rlc3 nrlc213_1 4404.19915397
Lrlc213 nrlc213_1 nrlc213_2 1
Crlc213 nrlc213_2 rlc8 5.72827147927e-11
* RLC[214] rlc3-rlc9
Rrlc214 rlc3 nrlc214_1 24.9136536005
Lrlc214 nrlc214_1 nrlc214_2 0.777380889876
Crlc214 nrlc214_2 rlc9 1.39160668842e-06
* RLC[215] rlc3-rlc10
Rrlc215 rlc3 nrlc215_1 18.2107578039
Lrlc215 nrlc215_1 nrlc215_2 1
Crlc215 nrlc215_2 rlc10 3.35043698115e-06
* RLC[216] rlc3-rlc11
Rrlc216 rlc3 nrlc216_1 4.2265347591
Lrlc216 nrlc216_1 nrlc216_2 1
Crlc216 nrlc216_2 rlc11 6.21997444839e-05
* RLC[217] rlc3-rlc12
Rrlc217 rlc3 nrlc217_1 3.57671868132
Lrlc217 nrlc217_1 nrlc217_2 1
Crlc217 nrlc217_2 rlc12 8.68536200413e-05
* RLC[219] rlc3-rlc14
Rrlc219 rlc3 nrlc219_1 49.0931418463
Lrlc219 nrlc219_1 nrlc219_2 7.63499564557e-07
Crlc219 nrlc219_2 rlc14 3.51985384494e-13
* RLC[221] rlc3-GND
Rrlc221 rlc3 nrlc221_1 15.3738900719
Lrlc221 nrlc221_1 nrlc221_2 1
Crlc221 nrlc221_2 GND 4.70099671547e-06
* RLC[222] rlc4-rlc5
Rrlc222 rlc4 nrlc222_1 38.3076779198
Lrlc222 nrlc222_1 nrlc222_2 0.0427212240344
Crlc222 nrlc222_2 rlc5 3.23466659374e-08
* RLC[223] rlc4-rlc6
Rrlc223 rlc4 nrlc223_1 31.0170859601
Lrlc223 nrlc223_1 nrlc223_2 1
Crlc223 nrlc223_2 rlc6 1.15492957643e-06
* RLC[226] rlc4-rlc9
Rrlc226 rlc4 nrlc226_1 8.97097516235
Lrlc226 nrlc226_1 nrlc226_2 1
Crlc226 nrlc226_2 rlc9 1.38063278485e-05
* RLC[227] rlc4-rlc10
Rrlc227 rlc4 nrlc227_1 3.62787396663
Lrlc227 nrlc227_1 nrlc227_2 0.305275984202
Crlc227 nrlc227_2 rlc10 2.57718591032e-05
* RLC[228] rlc4-rlc11
Rrlc228 rlc4 nrlc228_1 0.433067133552
Lrlc228 nrlc228_1 nrlc228_2 0.168792427946
Crlc228 nrlc228_2 rlc11 0.001
* RLC[231] rlc4-rlc14
Rrlc231 rlc4 nrlc231_1 2.22778472451
Lrlc231 nrlc231_1 nrlc231_2 1
Crlc231 nrlc231_2 rlc14 0.000223877808523
* RLC[232] rlc4-rlc15
Rrlc232 rlc4 nrlc232_1 0.856548773927
Lrlc232 nrlc232_1 nrlc232_2 0.660308221905
Crlc232 nrlc232_2 rlc15 0.001
* RLC[233] rlc4-GND
Rrlc233 rlc4 nrlc233_1 0.00116247844891
Lrlc233 nrlc233_1 nrlc233_2 2.20438045411e-09
Crlc233 nrlc233_2 GND 1.81248416727e-06
* RLC[235] rlc5-rlc7
Rrlc235 rlc5 nrlc235_1 199.336107404
Lrlc235 nrlc235_1 nrlc235_2 0.236838120457
Crlc235 nrlc235_2 rlc7 6.62273152884e-09
* RLC[237] rlc5-rlc9
Rrlc237 rlc5 nrlc237_1 351.66664641
Lrlc237 nrlc237_1 nrlc237_2 1
Crlc237 nrlc237_2 rlc9 8.98452519222e-09
* RLC[238] rlc5-rlc10
Rrlc238 rlc5 nrlc238_1 34021.2313245
Lrlc238 nrlc238_1 nrlc238_2 0.204342004231
Crlc238 nrlc238_2 rlc10 1.96162091552e-13
* RLC[239] rlc5-rlc11
Rrlc239 rlc5 nrlc239_1 12453.2303233
Lrlc239 nrlc239_1 nrlc239_2 1
Crlc239 nrlc239_2 rlc11 7.16462476024e-12
* RLC[240] rlc5-rlc12
Rrlc240 rlc5 nrlc240_1 1253.77652203
Lrlc240 nrlc240_1 nrlc240_2 0.982277615082
Crlc240 nrlc240_2 rlc12 6.9430688443e-10
* RLC[241] rlc5-rlc13
Rrlc241 rlc5 nrlc241_1 174.649119904
Lrlc241 nrlc241_1 nrlc241_2 1
Crlc241 nrlc241_2 rlc13 3.6427107519e-08
* RLC[244] rlc5-GND
Rrlc244 rlc5 nrlc244_1 1.05409255339
Lrlc244 nrlc244_1 nrlc244_2 1
Crlc244 nrlc244_2 GND 0.001
* RLC[246] rlc6-rlc8
Rrlc246 rlc6 nrlc246_1 0.0001
Lrlc246 nrlc246_1 nrlc246_2 7.10403970235e-16
Crlc246 nrlc246_2 rlc8 3.86992688623e-10
* RLC[248] rlc6-rlc10
Rrlc248 rlc6 nrlc248_1 0.000578892488529
Lrlc248 nrlc248_1 nrlc248_2 2.81724682145e-10
Crlc248 nrlc248_2 rlc10 9.34085347052e-07
* RLC[251] rlc6-rlc13
Rrlc251 rlc6 nrlc251_1 11.2606769577
Lrlc251 nrlc251_1 nrlc251_2 1
Crlc251 nrlc251_2 rlc13 8.76250928224e-06
* RLC[252] rlc6-rlc14
Rrlc252 rlc6 nrlc252_1 69.5125146253
Lrlc252 nrlc252_1 nrlc252_2 1
Crlc252 nrlc252_2 rlc14 2.299489822e-07
* RLC[254] rlc6-GND
Rrlc254 rlc6 nrlc254_1 33.1256704625
Lrlc254 nrlc254_1 nrlc254_2 1
Crlc254 nrlc254_2 GND 1.01257718145e-06
* RLC[256] rlc7-rlc9
Rrlc256 rlc7 nrlc256_1 12349.626032
Lrlc256 nrlc256_1 nrlc256_2 1
Crlc256 nrlc256_2 rlc9 7.28534088321e-12
* RLC[258] rlc7-rlc11
Rrlc258 rlc7 nrlc258_1 16.9532662155
Lrlc258 nrlc258_1 nrlc258_2 1
Crlc258 nrlc258_2 rlc11 3.86590098979e-06
* RLC[260] rlc7-rlc13
Rrlc260 rlc7 nrlc260_1 3732.37607777
Lrlc260 nrlc260_1 nrlc260_2 1
Crlc260 nrlc260_2 rlc13 7.97602848201e-11
* RLC[261] rlc7-rlc14
Rrlc261 rlc7 nrlc261_1 836.28707524
Lrlc261 nrlc261_1 nrlc261_2 1
Crlc261 nrlc261_2 rlc14 1.58871765171e-09
* RLC[262] rlc7-rlc15
Rrlc262 rlc7 nrlc262_1 143.591548377
Lrlc262 nrlc262_1 nrlc262_2 0.721691298952
Crlc262 nrlc262_2 rlc15 3.88911873693e-08
* RLC[263] rlc7-GND
Rrlc263 rlc7 nrlc263_1 14.4942182635
Lrlc263 nrlc263_1 nrlc263_2 1
Crlc263 nrlc263_2 GND 5.28893094537e-06
* RLC[267] rlc8-rlc12
Rrlc267 rlc8 nrlc267_1 510.796902021
Lrlc267 nrlc267_1 nrlc267_2 1
Crlc267 nrlc267_2 rlc12 4.25854245598e-09
* RLC[268] rlc8-rlc13
Rrlc268 rlc8 nrlc268_1 1.63448491728
Lrlc268 nrlc268_1 nrlc268_2 1
Crlc268 nrlc268_2 rlc13 0.000415906450271
* RLC[269] rlc8-rlc14
Rrlc269 rlc8 nrlc269_1 13.0544678615
Lrlc269 nrlc269_1 nrlc269_2 1
Crlc269 nrlc269_2 rlc14 6.519873113e-06
* RLC[271] rlc8-GND
Rrlc271 rlc8 nrlc271_1 0.0001
Lrlc271 nrlc271_1 nrlc271_2 2.68040058982e-16
Crlc271 nrlc271_2 GND 1.2557820589e-07
* RLC[272] rlc9-rlc10
Rrlc272 rlc9 nrlc272_1 11.0884513749
Lrlc272 nrlc272_1 nrlc272_2 1
Crlc272 nrlc272_2 rlc10 9.03682137327e-06
* RLC[273] rlc9-rlc11
Rrlc273 rlc9 nrlc273_1 120.199404268
Lrlc273 nrlc273_1 nrlc273_2 1
Crlc273 nrlc273_2 rlc11 7.69046960639e-08
* RLC[275] rlc9-rlc13
Rrlc275 rlc9 nrlc275_1 1.05409255339
Lrlc275 nrlc275_1 nrlc275_2 1
Crlc275 nrlc275_2 rlc13 0.001
* RLC[276] rlc9-rlc14
Rrlc276 rlc9 nrlc276_1 6.23700431351
Lrlc276 nrlc276_1 nrlc276_2 1
Crlc276 nrlc276_2 rlc14 2.85631040375e-05
* RLC[279] rlc10-rlc11
Rrlc279 rlc10 nrlc279_1 17.3186246885
Lrlc279 nrlc279_1 nrlc279_2 0.598223139255
Crlc279 nrlc279_2 rlc11 2.21612318127e-06
* RLC[280] rlc10-rlc12
Rrlc280 rlc10 nrlc280_1 10.567548592
Lrlc280 nrlc280_1 nrlc280_2 1
Crlc280 nrlc280_2 rlc12 9.94967702902e-06
* RLC[282] rlc10-rlc14
Rrlc282 rlc10 nrlc282_1 44.5878581717
Lrlc282 nrlc282_1 nrlc282_2 0.0177156847919
Crlc282 nrlc282_2 rlc14 9.90107186967e-09
* RLC[284] rlc10-GND
Rrlc284 rlc10 nrlc284_1 1.02645668079
Lrlc284 nrlc284_1 nrlc284_2 3.05734186656e-05
Crlc284 nrlc284_2 GND 3.22418714896e-08
* RLC[285] rlc11-rlc12
Rrlc285 rlc11 nrlc285_1 5679.72511864
Lrlc285 nrlc285_1 nrlc285_2 0.00568578027
Crlc285 nrlc285_2 rlc12 1.95836179169e-13
* RLC[288] rlc11-rlc15
Rrlc288 rlc11 nrlc288_1 10.9953695029
Lrlc288 nrlc288_1 nrlc288_2 1
Crlc288 nrlc288_2 rlc15 9.19047236431e-06
* RLC[289] rlc11-GND
Rrlc289 rlc11 nrlc289_1 615.689250666
Lrlc289 nrlc289_1 nrlc289_2 1
Crlc289 nrlc289_2 GND 2.93112505614e-09
* RLC[291] rlc12-rlc14
Rrlc291 rlc12 nrlc291_1 11.9636127778
Lrlc291 nrlc291_1 nrlc291_2 0.503995784817
Crlc291 nrlc291_2 rlc14 3.91254818319e-06
* RLC[293] rlc12-GND
Rrlc293 rlc12 nrlc293_1 1.05409255339
Lrlc293 nrlc293_1 nrlc293_2 1
Crlc293 nrlc293_2 GND 0.001
* RLC[294] rlc13-rlc14
Rrlc294 rlc13 nrlc294_1 52.5359377357
Lrlc294 nrlc294_1 nrlc294_2 1
Crlc294 nrlc294_2 rlc14 4.02572878955e-07
* RLC[296] rlc13-GND
Rrlc296 rlc13 nrlc296_1 436.599670628
Lrlc296 nrlc296_1 nrlc296_2 1
Crlc296 nrlc296_2 GND 5.82895473876e-09
* RLC[297] rlc14-rlc15
Rrlc297 rlc14 nrlc297_1 1654477.81798
Lrlc297 nrlc297_1 nrlc297_2 0.860864103066
Crlc297 nrlc297_2 rlc15 3.49438048711e-16
* RLC[298] rlc14-GND
Rrlc298 rlc14 nrlc298_1 246.811259989
Lrlc298 nrlc298_1 nrlc298_2 0.894199650378
Crlc298 nrlc298_2 GND 1.63103037106e-08
* RLC[299] rlc15-GND
Rrlc299 rlc15 nrlc299_1 1.02839658817
Lrlc299 nrlc299_1 nrlc299_2 0.951839588312
Crlc299 nrlc299_2 GND 0.001
* DC[0] P1A-P2A
Rdc0 P1A ndc0_1 0.0859088032433
Ldc0 ndc0_1 P2A 1.05840944458e-07
* DC[23] P3A-P4A
Rdc23 P3A ndc23_1 0.129897261863
Ldc23 ndc23_1 P4A 1.55771442743e-07
* DC[43] P1B-P3B
Rdc43 P1B ndc43_1 0.000632541923572
Ldc43 ndc43_1 P3B 3.82732751637e-09
* DC[46] P1B-dc1
Rdc46 P1B ndc46_1 0.000316929365883
Ldc46 ndc46_1 dc1 5.18954338445e-08
* DC[52] P2B-dc0
Rdc52 P2B ndc52_1 0.00034465623442
Ldc52 ndc52_1 dc0 3.39350188676e-09
* DC[54] P2B-dc2
Rdc54 P2B ndc54_1 0.0448800393763
Ldc54 ndc54_1 dc2 7.14288011289e-09
* DC[57] P3B-P4B
Rdc57 P3B ndc57_1 0.0189777860963
Ldc57 ndc57_1 P4B 4.75001754559e-08
* DC[61] P3B-dc3
Rdc61 P3B ndc61_1 0.00186577512331
Ldc61 ndc61_1 dc3 8.07548732912e-08
* DC[63] P4B-dc0
Rdc63 P4B ndc63_1 0.000376401727004
Ldc63 ndc63_1 dc0 5.9906195441e-11
* DC[65] P4B-dc2
Rdc65 P4B ndc65_1 0.0152798865134
Ldc65 ndc65_1 dc2 6.68237702303e-07
* DC[66] P4B-dc3
Rdc66 P4B ndc66_1 0.00184280419914
Ldc66 ndc66_1 dc3 2.93291397444e-10
* DC[70] dc0-dc3
Rdc70 dc0 ndc70_1 0.0001
Ldc70 ndc70_1 dc3 3.62949350019e-09
* DC[72] dc1-dc2
Rdc72 dc1 ndc72_1 0.0001
Ldc72 ndc72_1 dc2 3.80602283919e-08
* DC[75] dc2-dc3
Rdc75 dc2 ndc75_1 0.00245703174357
Ldc75 ndc75_1 dc3 1.62079193563e-07
* ---- leaks
Rleak_P1A P1A GND 1e+12
Rleak_P1B P1B GND 1e+12
Rleak_P2A P2A GND 1e+12
Rleak_P2B P2B GND 1e+12
Rleak_P3A P3A GND 1e+12
Rleak_P3B P3B GND 1e+12
Rleak_P4A P4A GND 1e+12
Rleak_P4B P4B GND 1e+12
Rleak_dc0 dc0 GND 1e+12
Rleak_dc1 dc1 GND 1e+12
Rleak_dc2 dc2 GND 1e+12
Rleak_dc3 dc3 GND 1e+12
Rleak_rlc0 rlc0 GND 1e+12
Rleak_rlc1 rlc1 GND 1e+12
Rleak_rlc10 rlc10 GND 1e+12
Rleak_rlc11 rlc11 GND 1e+12
Rleak_rlc12 rlc12 GND 1e+12
Rleak_rlc13 rlc13 GND 1e+12
Rleak_rlc14 rlc14 GND 1e+12
Rleak_rlc15 rlc15 GND 1e+12
Rleak_rlc2 rlc2 GND 1e+12
Rleak_rlc3 rlc3 GND 1e+12
Rleak_rlc4 rlc4 GND 1e+12
Rleak_rlc5 rlc5 GND 1e+12
Rleak_rlc6 rlc6 GND 1e+12
Rleak_rlc7 rlc7 GND 1e+12
Rleak_rlc8 rlc8 GND 1e+12
Rleak_rlc9 rlc9 GND 1e+12
.ends fitted
